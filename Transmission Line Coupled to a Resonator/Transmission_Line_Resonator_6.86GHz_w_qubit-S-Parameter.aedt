# Ansys Electronics Desktop project, version 2026.1
materials:
  vacuum: permittivity=1
  silicon: permittivity=11.9

design TL_and_Resonator_Scatter1 (HFSS, Eigenmode, model units mm)
geometry:
  prime_cpw_TQ1_path = polyline((-0.0005, -0.0011, 0) (0, -0.0011, 0))
  prime_cpw_TQ1 = polyline((-0.0005, -0.001095, 0) (-0.0005, -0.001105, 0))
  prime_cpw_TQ1.sweep_along_path(prime_cpw_TQ1_path)
  prime_cpw_sub_TQ1_path = polyline((-0.0005, -0.0011, 0) (0, -0.0011, 0))
  prime_cpw_sub_TQ1 = polyline((-0.0005, -0.001089194, 0) (-0.0005, -0.001110806, 0))
  prime_cpw_sub_TQ1.sweep_along_path(prime_cpw_sub_TQ1_path)
  second_cpw_TQ1_path = polyline(z=0, xy: (-0.000375, -0.001124612) (-0.000125, -0.001124612) (-0.000125, -0.001224612))
  second_cpw_TQ1_path.fillet(Vertices=second_cpw_TQ1_path.vertex(at (-0.125, -1.12461, 0)) Radius=2.5e-05 Setback=0mm)
  second_cpw_TQ1 = polyline((-0.000375, -0.001119612, 0) (-0.000375, -0.001129612, 0))
  second_cpw_TQ1.sweep_along_path(second_cpw_TQ1_path)
  second_cpw_sub_TQ1_path = polyline(z=0, xy: (-0.000375, -0.001124612) (-0.000125, -0.001124612) (-0.000125, -0.001224612))
  second_cpw_sub_TQ1_path.fillet(Vertices=second_cpw_sub_TQ1_path.vertex(at (-0.125, -1.12461, 0)) Radius=2.5e-05 Setback=0mm)
  second_cpw_sub_TQ1 = polyline((-0.000375, -0.001113806, 0) (-0.000375, -0.001135418, 0))
  second_cpw_sub_TQ1.sweep_along_path(second_cpw_sub_TQ1_path)
  trace_cpw_left_path = polyline((0.002015, -0.0011, 0) (0, -0.0011, 0))
  trace_cpw_left = polyline((0.002015, -0.001105, 0) (0.002015, -0.001095, 0))
  trace_cpw_left.sweep_along_path(trace_cpw_left_path)
  cut_cpw_left_path = polyline((0.002015, -0.0011, 0) (0, -0.0011, 0))
  cut_cpw_left = polyline((0.002015, -0.001110806, 0) (0.002015, -0.001089194, 0))
  cut_cpw_left.sweep_along_path(cut_cpw_left_path)
  trace_cpw_right_path = polyline((-0.0005, -0.0011, 0) (-0.002015, -0.0011, 0))
  trace_cpw_right = polyline((-0.0005, -0.001105, 0) (-0.0005, -0.001095, 0))
  trace_cpw_right.sweep_along_path(trace_cpw_right_path)
  cut_cpw_right_path = polyline((-0.0005, -0.0011, 0) (-0.002015, -0.0011, 0))
  cut_cpw_right = polyline((-0.0005, -0.001110806, 0) (-0.0005, -0.001089194, 0))
  cut_cpw_right.sweep_along_path(cut_cpw_right_path)
  b_wire_Q0_bottom_path = polyline(z=0, xy: (-0.00145, -0.00158) (-0.001425, -0.00158) (-0.00133, -0.00158) (-0.001225, -0.00158))
  b_wire_Q0_bottom = polyline((-0.00145, -0.001575, 0) (-0.00145, -0.001585, 0))
  b_wire_Q0_bottom.sweep_along_path(b_wire_Q0_bottom_path)
  b_wire_sub_Q0_bottom_path = polyline(z=0, xy: (-0.00145, -0.00158) (-0.001425, -0.00158) (-0.00133, -0.00158) (-0.001225, -0.00158))
  b_wire_sub_Q0_bottom = polyline((-0.00145, -0.001569194, 0) (-0.00145, -0.001590806, 0))
  b_wire_sub_Q0_bottom.sweep_along_path(b_wire_sub_Q0_bottom_path)
  trace_meander_Q0_bottom_path = polyline(z=0, xy: (-0.000125, -0.001224612) (-0.000125, -0.0017110358) (-0.000215, -0.0017110358) (-0.000215, -0.0011381882) (-0.000305, -0.0011381882) (-0.000305, -0.0017110358) (-0.000395, -0.0017110358) (-0.000395, -0.0011381882) (-0.000485, -0.0011381882) (-0.000485, -0.0017110358) (-0.000575, -0.0017110358) (-0.000575, -0.00158) (-0.001225, -0.00158))
  trace_meander_Q0_bottom_path.fillet(Vertices=trace_meander_Q0_bottom_path.vertex(at (-0.575, -1.58, 0), at (-0.575, -1.71104, 0), at (-0.485, -1.71104, 0), at (-0.485, -1.13819, 0), at (-0.395, -1.13819, 0), at (-0.395, -1.71104, 0), at (-0.305, -1.71104, 0), at (-0.305, -1.13819, 0), at (-0.215, -1.13819, 0), at (-0.215, -1.71104, 0), at (-0.125, -1.71104, 0)) Radius=4e-05 Setback=0mm)
  trace_meander_Q0_bottom = polyline((-0.00012, -0.001224612, 0) (-0.00013, -0.001224612, 0))
  trace_meander_Q0_bottom.sweep_along_path(trace_meander_Q0_bottom_path)
  cut_meander_Q0_bottom_path = polyline(z=0, xy: (-0.000125, -0.001224612) (-0.000125, -0.0017110358) (-0.000215, -0.0017110358) (-0.000215, -0.0011381882) (-0.000305, -0.0011381882) (-0.000305, -0.0017110358) (-0.000395, -0.0017110358) (-0.000395, -0.0011381882) (-0.000485, -0.0011381882) (-0.000485, -0.0017110358) (-0.000575, -0.0017110358) (-0.000575, -0.00158) (-0.001225, -0.00158))
  cut_meander_Q0_bottom_path.fillet(Vertices=cut_meander_Q0_bottom_path.vertex(at (-0.575, -1.58, 0), at (-0.575, -1.71104, 0), at (-0.485, -1.71104, 0), at (-0.485, -1.13819, 0), at (-0.395, -1.13819, 0), at (-0.395, -1.71104, 0), at (-0.305, -1.71104, 0), at (-0.305, -1.13819, 0), at (-0.215, -1.13819, 0), at (-0.215, -1.71104, 0), at (-0.125, -1.71104, 0)) Radius=4e-05 Setback=0mm)
  cut_meander_Q0_bottom = polyline((-0.000114194, -0.001224612, 0) (-0.000135806, -0.001224612, 0))
  cut_meander_Q0_bottom.sweep_along_path(cut_meander_Q0_bottom_path)
  launch_pad_Transmission_Launch_Pad_L = polyline(z=0, xy: (-0.00204, -0.001095) (-0.002162, -0.00106) (-0.002242, -0.00106) (-0.002242, -0.00114) (-0.002162, -0.00114) (-0.00204, -0.001105) (-0.002015, -0.001105) (-0.002015, -0.001095) (-0.00204, -0.001095), closed, covered)
  pocket_Transmission_Launch_Pad_L = polyline(z=0, xy: (-0.00204, -0.001089194) (-0.002162, -0.001002) (-0.0023, -0.001002) (-0.0023, -0.001198) (-0.002162, -0.001198) (-0.00204, -0.001110806) (-0.002015, -0.001110806) (-0.002015, -0.001089194) (-0.00204, -0.001089194), closed, covered)
  launch_pad_Transmission_Launch_Pad_R = polyline(z=0, xy: (0.00204, -0.001105) (0.002162, -0.00114) (0.002242, -0.00114) (0.002242, -0.00106) (0.002162, -0.00106) (0.00204, -0.001095) (0.002015, -0.001095) (0.002015, -0.001105) (0.00204, -0.001105), closed, covered)
  pocket_Transmission_Launch_Pad_R = polyline(z=0, xy: (0.00204, -0.001110806) (0.002162, -0.001198) (0.0023, -0.001198) (0.0023, -0.001002) (0.002162, -0.001002) (0.00204, -0.001089194) (0.002015, -0.001089194) (0.002015, -0.001110806) (0.00204, -0.001110806), closed, covered)
  pad_top_Q0_bottom = polyline(z=0, xy: (-0.0018549009, -0.0017297592) (-0.0018597545, -0.0017290393) (-0.0018645142, -0.001727847) (-0.0018691342, -0.001726194) (-0.0018735698, -0.0017240961) (-0.0018777785, -0.0017215735) (-0.0018817197, -0.0017186505) (-0.0018853553, -0.0017153553) (-0.0018886505, -0.0017117197) (-0.0018915735, -0.0017077785) (-0.0018940961, -0.0017035698) (-0.001896194, -0.0016991342) (-0.001897847, -0.0016945142) (-0.0018990393, -0.0016897545) (-0.0018997592, -0.0016849009) (-0.0019, -0.00168) (-0.0018997592, -0.0016750991) (-0.0018990393, -0.0016702455) (-0.001897847, -0.0016654858) (-0.001896194, -0.0016608658) (-0.0018940961, -0.0016564302) (-0.0018915735, -0.0016522215) (-0.0018886505, -0.0016482803) (-0.0018853553, -0.0016446447) (-0.0018817197, -0.0016413495) (-0.0018777785, -0.0016384265) (-0.0018735698, -0.0016359039) (-0.0018691342, -0.001633806) (-0.0018645142, -0.001632153) (-0.0018597545, -0.0016309607) (-0.0018549009, -0.0016302408) (-0.00185, -0.00163) (-0.00145, -0.00163) (-0.0014450991, -0.0016302408) (-0.0014402455, -0.0016309607) (-0.0014354858, -0.001632153) (-0.0014308658, -0.001633806) (-0.0014264302, -0.0016359039) (-0.0014222215, -0.0016384265) (-0.0014182803, -0.0016413495) (-0.0014146447, -0.0016446447) (-0.0014113495, -0.0016482803) (-0.0014084265, -0.0016522215) (-0.0014059039, -0.0016564302) (-0.001403806, -0.0016608658) (-0.001402153, -0.0016654858) (-0.0014009607, -0.0016702455) (-0.0014002408, -0.0016750991) (-0.0014, -0.00168) (-0.0014002408, -0.0016849009) (-0.0014009607, -0.0016897545) (-0.001402153, -0.0016945142) (-0.001403806, -0.0016991342) (-0.0014059039, -0.0017035698) (-0.0014084265, -0.0017077785) (-0.0014113495, -0.0017117197) (-0.0014146447, -0.0017153553) (-0.0014182803, -0.0017186505) (-0.0014222215, -0.0017215735) (-0.0014264302, -0.0017240961) (-0.0014308658, -0.001726194) (-0.0014354858, -0.001727847) (-0.0014402455, -0.0017290393) (-0.0014450991, -0.0017297592) (-0.00145, -0.00173) (-0.00185, -0.00173) (-0.0018549009, -0.0017297592), closed, covered)
  rect_pk_Q0_bottom = rectangle(corner=(-0.001975, -0.00179, 0), x_size=0.00065, y_size=0.000325)
  b_connector_pad_Q0_bottom = rectangle(corner=(-0.001575, -0.001585, 0), x_size=0.000125, y_size=1e-05)
  JJ_rect_Lj_Q0_bottom_rect_jj_R = rectangle(corner=(-0.00164, -0.00179, 0), x_size=2e-05, y_size=6e-05)
  JJ_Lj_Q0_bottom_rect_jj_R_ = polyline((-0.00163, -0.00179, 0) (-0.00163, -0.00173, 0))
  JJ_rect_Lj_Q0_bottom_rect_jj_L = rectangle(corner=(-0.00168, -0.00179, 0), x_size=2e-05, y_size=6e-05)
  JJ_Lj_Q0_bottom_rect_jj_L_ = polyline((-0.00167, -0.00179, 0) (-0.00167, -0.00173, 0))
  ground_main_plane = rectangle(corner=(-0.0025, -0.00199, 0), x_size=0.005, y_size=0.001188)
  main [silicon] = box(corner=(-0.0025, -0.00199, -0.00075), size=(0.005, 0.001188, 0.00075))
  sample_holder [vacuum] = box(corner=(-0.0025, -0.00199, -0.00165), size=(0.005, 0.001188, 0.00254))
  ground_main_plane.subtract(pocket_Transmission_Launch_Pad_L, cut_cpw_left, cut_meander_Q0_bottom, rect_pk_Q0_bottom, cut_cpw_right, pocket_Transmission_Launch_Pad_R, b_wire_sub_Q0_bottom, second_cpw_sub_TQ1, prime_cpw_sub_TQ1)
  Rectangle1 = rectangle(corner=(-2.3mm, -1.198mm, 0mm), x_size=0.058mm, y_size=0.196mm)
  Rectangle2 = rectangle(corner=(2.3mm, -1.198mm, 0mm), x_size=-0.058mm, y_size=0.196mm)
boundaries and excitations:
  PerfE: Perfect E Objects=[prime_cpw_TQ1, second_cpw_TQ1, trace_cpw_left, trace_cpw_right, b_wire_Q0_bottom, trace_meander_Q0_bottom, launch_pad_Transmission_Launch_Pad_L, launch_pad_Transmission_Launch_Pad_R, pad_top_Q0_bottom, b_connector_pad_Q0_bottom, ground_main_plane]
  LumpRLC1: Lumped RLC Objects=Rectangle1 CurrentLine{(-2.3, -1.08, 0) -> (-2.242, -1.082, 0)} RLC_Type=Parallel Resistance=50ohm
  LumpRLC2: Lumped RLC Objects=Rectangle2 CurrentLine{(2.3, -1.082, 0) -> (2.242, -1.08, 0)} RLC_Type=Parallel Resistance=50ohm
mesh:
  small_mesh: LengthBased Objects=[JJ_rect_Lj_Q0_bottom_rect_jj_R, JJ_rect_Lj_Q0_bottom_rect_jj_L] MaxLength=7um
setups:
  Setup: HfssEigen MinimumFrequency=1GHz NumModes=6 MaxDeltaFreq=0.5 ConvergeOnRealFreq=true MaximumPasses=18 MinimumPasses=12 MinimumConvergedPasses=3 PercentRefinement=30 BasisOrder=-1
source amplitudes:
  #-10:1: 1 0deg
  #-10:2, #-10:4, #-10:5, #-10:6: 0V_per_meter 0deg
  #-10:3: 0 0deg
field plots:
  Mag_E1, Mag_E2: E Field on Setup : LastAdaptive at Phase=0deg
  Mesh1, Mesh2: MeshPlots on Setup : LastAdaptive at Phase=0deg
reports:
  Eigen Modes Plot1: re(Mode(1)), re(Mode(2)), re(Mode(3)), re(Mode(4)), re(Mode(5)), re(Mode(6)) vs Pass on Setup : AdaptivePass
  Eigen Q Plot1: Q(1), Q(2), Q(3), Q(4), Q(5), Q(6) vs Pass on Setup : AdaptivePass

design TL_and_Resonator_Scatter4 (HFSS, HFSS Hybrid Modal Network, model units mm)
geometry:
  prime_cpw_TQ1_path = polyline((-0.0005, -0.0011, 0) (0, -0.0011, 0))
  prime_cpw_TQ1 = polyline((-0.0005, -0.001095, 0) (-0.0005, -0.001105, 0))
  prime_cpw_TQ1.sweep_along_path(prime_cpw_TQ1_path)
  prime_cpw_sub_TQ1_path = polyline((-0.0005, -0.0011, 0) (0, -0.0011, 0))
  prime_cpw_sub_TQ1 = polyline((-0.0005, -0.001089194, 0) (-0.0005, -0.001110806, 0))
  prime_cpw_sub_TQ1.sweep_along_path(prime_cpw_sub_TQ1_path)
  second_cpw_TQ1_path = polyline(z=0, xy: (-0.000375, -0.001124612) (-0.000125, -0.001124612) (-0.000125, -0.001224612))
  second_cpw_TQ1_path.fillet(Vertices=second_cpw_TQ1_path.vertex(at (-0.125, -1.12461, 0)) Radius=2.5e-05 Setback=0mm)
  second_cpw_TQ1 = polyline((-0.000375, -0.001119612, 0) (-0.000375, -0.001129612, 0))
  second_cpw_TQ1.sweep_along_path(second_cpw_TQ1_path)
  second_cpw_sub_TQ1_path = polyline(z=0, xy: (-0.000375, -0.001124612) (-0.000125, -0.001124612) (-0.000125, -0.001224612))
  second_cpw_sub_TQ1_path.fillet(Vertices=second_cpw_sub_TQ1_path.vertex(at (-0.125, -1.12461, 0)) Radius=2.5e-05 Setback=0mm)
  second_cpw_sub_TQ1 = polyline((-0.000375, -0.001113806, 0) (-0.000375, -0.001135418, 0))
  second_cpw_sub_TQ1.sweep_along_path(second_cpw_sub_TQ1_path)
  trace_cpw_left_path = polyline((0.002015, -0.0011, 0) (0, -0.0011, 0))
  trace_cpw_left = polyline((0.002015, -0.001105, 0) (0.002015, -0.001095, 0))
  trace_cpw_left.sweep_along_path(trace_cpw_left_path)
  cut_cpw_left_path = polyline((0.002015, -0.0011, 0) (0, -0.0011, 0))
  cut_cpw_left = polyline((0.002015, -0.001110806, 0) (0.002015, -0.001089194, 0))
  cut_cpw_left.sweep_along_path(cut_cpw_left_path)
  trace_cpw_right_path = polyline((-0.0005, -0.0011, 0) (-0.002015, -0.0011, 0))
  trace_cpw_right = polyline((-0.0005, -0.001105, 0) (-0.0005, -0.001095, 0))
  trace_cpw_right.sweep_along_path(trace_cpw_right_path)
  cut_cpw_right_path = polyline((-0.0005, -0.0011, 0) (-0.002015, -0.0011, 0))
  cut_cpw_right = polyline((-0.0005, -0.001110806, 0) (-0.0005, -0.001089194, 0))
  cut_cpw_right.sweep_along_path(cut_cpw_right_path)
  b_wire_Q0_bottom_path = polyline(z=0, xy: (-0.00145, -0.00158) (-0.001425, -0.00158) (-0.00133, -0.00158) (-0.001225, -0.00158))
  b_wire_Q0_bottom = polyline((-0.00145, -0.001575, 0) (-0.00145, -0.001585, 0))
  b_wire_Q0_bottom.sweep_along_path(b_wire_Q0_bottom_path)
  b_wire_sub_Q0_bottom_path = polyline(z=0, xy: (-0.00145, -0.00158) (-0.001425, -0.00158) (-0.00133, -0.00158) (-0.001225, -0.00158))
  b_wire_sub_Q0_bottom = polyline((-0.00145, -0.001569194, 0) (-0.00145, -0.001590806, 0))
  b_wire_sub_Q0_bottom.sweep_along_path(b_wire_sub_Q0_bottom_path)
  trace_meander_Q0_bottom_path = polyline(z=0, xy: (-0.000125, -0.001224612) (-0.000125, -0.0017110358) (-0.000215, -0.0017110358) (-0.000215, -0.0011381882) (-0.000305, -0.0011381882) (-0.000305, -0.0017110358) (-0.000395, -0.0017110358) (-0.000395, -0.0011381882) (-0.000485, -0.0011381882) (-0.000485, -0.0017110358) (-0.000575, -0.0017110358) (-0.000575, -0.00158) (-0.001225, -0.00158))
  trace_meander_Q0_bottom_path.fillet(Vertices=trace_meander_Q0_bottom_path.vertex(at (-0.575, -1.58, 0), at (-0.575, -1.71104, 0), at (-0.485, -1.71104, 0), at (-0.485, -1.13819, 0), at (-0.395, -1.13819, 0), at (-0.395, -1.71104, 0), at (-0.305, -1.71104, 0), at (-0.305, -1.13819, 0), at (-0.215, -1.13819, 0), at (-0.215, -1.71104, 0), at (-0.125, -1.71104, 0)) Radius=4e-05 Setback=0mm)
  trace_meander_Q0_bottom = polyline((-0.00012, -0.001224612, 0) (-0.00013, -0.001224612, 0))
  trace_meander_Q0_bottom.sweep_along_path(trace_meander_Q0_bottom_path)
  cut_meander_Q0_bottom_path = polyline(z=0, xy: (-0.000125, -0.001224612) (-0.000125, -0.0017110358) (-0.000215, -0.0017110358) (-0.000215, -0.0011381882) (-0.000305, -0.0011381882) (-0.000305, -0.0017110358) (-0.000395, -0.0017110358) (-0.000395, -0.0011381882) (-0.000485, -0.0011381882) (-0.000485, -0.0017110358) (-0.000575, -0.0017110358) (-0.000575, -0.00158) (-0.001225, -0.00158))
  cut_meander_Q0_bottom_path.fillet(Vertices=cut_meander_Q0_bottom_path.vertex(at (-0.575, -1.58, 0), at (-0.575, -1.71104, 0), at (-0.485, -1.71104, 0), at (-0.485, -1.13819, 0), at (-0.395, -1.13819, 0), at (-0.395, -1.71104, 0), at (-0.305, -1.71104, 0), at (-0.305, -1.13819, 0), at (-0.215, -1.13819, 0), at (-0.215, -1.71104, 0), at (-0.125, -1.71104, 0)) Radius=4e-05 Setback=0mm)
  cut_meander_Q0_bottom = polyline((-0.000114194, -0.001224612, 0) (-0.000135806, -0.001224612, 0))
  cut_meander_Q0_bottom.sweep_along_path(cut_meander_Q0_bottom_path)
  launch_pad_Transmission_Launch_Pad_L = polyline(z=0, xy: (-0.00204, -0.001095) (-0.002162, -0.00106) (-0.002242, -0.00106) (-0.002242, -0.00114) (-0.002162, -0.00114) (-0.00204, -0.001105) (-0.002015, -0.001105) (-0.002015, -0.001095) (-0.00204, -0.001095), closed, covered)
  pocket_Transmission_Launch_Pad_L = polyline(z=0, xy: (-0.00204, -0.001089194) (-0.002162, -0.001002) (-0.0023, -0.001002) (-0.0023, -0.001198) (-0.002162, -0.001198) (-0.00204, -0.001110806) (-0.002015, -0.001110806) (-0.002015, -0.001089194) (-0.00204, -0.001089194), closed, covered)
  launch_pad_Transmission_Launch_Pad_R = polyline(z=0, xy: (0.00204, -0.001105) (0.002162, -0.00114) (0.002242, -0.00114) (0.002242, -0.00106) (0.002162, -0.00106) (0.00204, -0.001095) (0.002015, -0.001095) (0.002015, -0.001105) (0.00204, -0.001105), closed, covered)
  pocket_Transmission_Launch_Pad_R = polyline(z=0, xy: (0.00204, -0.001110806) (0.002162, -0.001198) (0.0023, -0.001198) (0.0023, -0.001002) (0.002162, -0.001002) (0.00204, -0.001089194) (0.002015, -0.001089194) (0.002015, -0.001110806) (0.00204, -0.001110806), closed, covered)
  pad_top_Q0_bottom = polyline(z=0, xy: (-0.0018549009, -0.0017297592) (-0.0018597545, -0.0017290393) (-0.0018645142, -0.001727847) (-0.0018691342, -0.001726194) (-0.0018735698, -0.0017240961) (-0.0018777785, -0.0017215735) (-0.0018817197, -0.0017186505) (-0.0018853553, -0.0017153553) (-0.0018886505, -0.0017117197) (-0.0018915735, -0.0017077785) (-0.0018940961, -0.0017035698) (-0.001896194, -0.0016991342) (-0.001897847, -0.0016945142) (-0.0018990393, -0.0016897545) (-0.0018997592, -0.0016849009) (-0.0019, -0.00168) (-0.0018997592, -0.0016750991) (-0.0018990393, -0.0016702455) (-0.001897847, -0.0016654858) (-0.001896194, -0.0016608658) (-0.0018940961, -0.0016564302) (-0.0018915735, -0.0016522215) (-0.0018886505, -0.0016482803) (-0.0018853553, -0.0016446447) (-0.0018817197, -0.0016413495) (-0.0018777785, -0.0016384265) (-0.0018735698, -0.0016359039) (-0.0018691342, -0.001633806) (-0.0018645142, -0.001632153) (-0.0018597545, -0.0016309607) (-0.0018549009, -0.0016302408) (-0.00185, -0.00163) (-0.00145, -0.00163) (-0.0014450991, -0.0016302408) (-0.0014402455, -0.0016309607) (-0.0014354858, -0.001632153) (-0.0014308658, -0.001633806) (-0.0014264302, -0.0016359039) (-0.0014222215, -0.0016384265) (-0.0014182803, -0.0016413495) (-0.0014146447, -0.0016446447) (-0.0014113495, -0.0016482803) (-0.0014084265, -0.0016522215) (-0.0014059039, -0.0016564302) (-0.001403806, -0.0016608658) (-0.001402153, -0.0016654858) (-0.0014009607, -0.0016702455) (-0.0014002408, -0.0016750991) (-0.0014, -0.00168) (-0.0014002408, -0.0016849009) (-0.0014009607, -0.0016897545) (-0.001402153, -0.0016945142) (-0.001403806, -0.0016991342) (-0.0014059039, -0.0017035698) (-0.0014084265, -0.0017077785) (-0.0014113495, -0.0017117197) (-0.0014146447, -0.0017153553) (-0.0014182803, -0.0017186505) (-0.0014222215, -0.0017215735) (-0.0014264302, -0.0017240961) (-0.0014308658, -0.001726194) (-0.0014354858, -0.001727847) (-0.0014402455, -0.0017290393) (-0.0014450991, -0.0017297592) (-0.00145, -0.00173) (-0.00185, -0.00173) (-0.0018549009, -0.0017297592), closed, covered)
  rect_pk_Q0_bottom = rectangle(corner=(-0.001975, -0.00179, 0), x_size=0.00065, y_size=0.000325)
  b_connector_pad_Q0_bottom = rectangle(corner=(-0.001575, -0.001585, 0), x_size=0.000125, y_size=1e-05)
  JJ_rect_Lj_Q0_bottom_rect_jj_R = rectangle(corner=(-0.00164, -0.00179, 0), x_size=2e-05, y_size=6e-05)
  JJ_Lj_Q0_bottom_rect_jj_R_ = polyline((-0.00163, -0.00179, 0) (-0.00163, -0.00173, 0))
  JJ_rect_Lj_Q0_bottom_rect_jj_L = rectangle(corner=(-0.00168, -0.00179, 0), x_size=2e-05, y_size=6e-05)
  JJ_Lj_Q0_bottom_rect_jj_L_ = polyline((-0.00167, -0.00179, 0) (-0.00167, -0.00173, 0))
  ground_main_plane = rectangle(corner=(-0.0025, -0.00199, 0), x_size=0.005, y_size=0.001188)
  main [silicon] = box(corner=(-0.0025, -0.00199, -0.00075), size=(0.005, 0.001188, 0.00075))
  sample_holder [vacuum] = box(corner=(-0.0025, -0.00199, -0.00165), size=(0.005, 0.001188, 0.00254))
  ground_main_plane.subtract(pocket_Transmission_Launch_Pad_L, cut_cpw_left, cut_meander_Q0_bottom, rect_pk_Q0_bottom, cut_cpw_right, pocket_Transmission_Launch_Pad_R, b_wire_sub_Q0_bottom, second_cpw_sub_TQ1, prime_cpw_sub_TQ1)
  Rectangle1 = rectangle(corner=(-2.3mm, -1.198mm, 0mm), x_size=0.058mm, y_size=0.196mm)
  Rectangle2 = rectangle(corner=(2.3mm, -1.198mm, 0mm), x_size=-0.058mm, y_size=0.196mm)
boundaries and excitations:
  PerfE: Perfect E Objects=[prime_cpw_TQ1, second_cpw_TQ1, trace_cpw_left, trace_cpw_right, b_wire_Q0_bottom, trace_meander_Q0_bottom, launch_pad_Transmission_Launch_Pad_L, launch_pad_Transmission_Launch_Pad_R, pad_top_Q0_bottom, b_connector_pad_Q0_bottom, ground_main_plane]
  1: Lumped Port Objects=Rectangle1 LumpedPortType=Default Modes{Mode1{IntLine{(-2.3, -1.095, 0) -> (-2.242, -1.096, 0)} CharImp=Zpi}} Impedance=50ohm
  2: Lumped Port Objects=Rectangle2 LumpedPortType=Default Modes{Mode1{IntLine{(2.3, -1.105, 0) -> (2.242, -1.104, 0)} CharImp=Zpi}} Impedance=50ohm
mesh:
  small_mesh: LengthBased Objects=[JJ_rect_Lj_Q0_bottom_rect_jj_R, JJ_rect_Lj_Q0_bottom_rect_jj_L] MaxLength=7um
setups:
  Setup1: HfssDriven Frequency=5GHz MaxDeltaS=0.02 MaximumPasses=3 MinimumPasses=3 MinimumConvergedPasses=1 PercentRefinement=30 MeshLink{ImportMesh LinkID=397 Project="This Project*" Product=HFSS Design=TL_and_Resonator_Scatter1 ForceSourceToSolve PathRelativeTo=TargetProject ApplyMeshOp} BasisOrder=1 DoLambdaRefine=false PortAccuracy=2 DrivenSolverType="Direct Solver"
    sweep Sweep: 6.5GHz to 6.5GHz, 201 points; 6.78GHz to 6.82GHz, 51 points; Type=Interpolating InterpTolerance=0.5 InterpMaxSolns=250 InterpUsePortImped=false PassivityErrorTolerance=0.0001
source amplitudes:
  1:1: 1W 0deg
  2:1: 0W 0deg
field plots:
  Mesh1: MeshPlots in main on Setup1 : LastAdaptive at Freq=5GHz Phase=0deg
reports:
  S Parameter Plot1: dB(S(1,1)), dB(S(2,1)) vs Freq on Setup1 : Sweep; markers m1 at 6.8064GHz
