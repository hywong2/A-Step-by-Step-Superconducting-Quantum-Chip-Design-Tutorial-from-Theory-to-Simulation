# Ansys Electronics Desktop project, version 2024.2
materials:
  vacuum: permittivity=1
  silicon: permittivity=11.9
  air: permittivity=1.0006 permeability=1.0000004
  vacuum - 0.001 DLT: permittivity=1 dielectric_loss_tangent=0.001
  vacuum - 1E-4 DLT: permittivity=1 dielectric_loss_tangent=0.0001
  vacuum - 1E-5 DLT: permittivity=1 dielectric_loss_tangent=1e-05
  vacuum - 1E-6 DLT: permittivity=1 dielectric_loss_tangent=1e-06
  copper: permeability=0.999991 conductivity=58000000
  pec: conductivity=1e+30
  vacuum - 1E-7 DLT: permittivity=1 dielectric_loss_tangent=1e-07
  vacuum - 1E-8 DLT: permittivity=1 dielectric_loss_tangent=1e-08
  vacuum - 5E-5 DLT: permittivity=1 dielectric_loss_tangent=5e-05
  vacuum - 5E-6 DLT: permittivity=1 dielectric_loss_tangent=5e-06

design transmission_bottom_line (HFSS, HFSS Hybrid Modal Network, model units mm)
variables:
  port_impedance = 50ohm
geometry:
  trace_cpw_straight_line_path = polyline((-0.002015, -0.0011, 0) (0.002015, -0.0011, 0))
  trace_cpw_straight_line = polyline((-0.002015, -0.001095, 0) (-0.002015, -0.001105, 0))
  trace_cpw_straight_line.sweep_along_path(trace_cpw_straight_line_path)
  cut_cpw_straight_line_path = polyline((-0.002015, -0.0011, 0) (0.002015, -0.0011, 0))
  cut_cpw_straight_line = polyline((-0.002015, -0.001089194, 0) (-0.002015, -0.001110806, 0))
  cut_cpw_straight_line.sweep_along_path(cut_cpw_straight_line_path)
  launch_pad_Transmission_Launch_Pad_L = polyline(z=0, xy: (-0.00204, -0.001095) (-0.002162, -0.00106) (-0.002242, -0.00106) (-0.002242, -0.00114) (-0.002162, -0.00114) (-0.00204, -0.001105) (-0.002015, -0.001105) (-0.002015, -0.001095) (-0.00204, -0.001095), closed, covered)
  pocket_Transmission_Launch_Pad_L = polyline(z=0, xy: (-0.00204, -0.001089194) (-0.002162, -0.001002) (-0.0023, -0.001002) (-0.0023, -0.001198) (-0.002162, -0.001198) (-0.00204, -0.001110806) (-0.002015, -0.001110806) (-0.002015, -0.001089194) (-0.00204, -0.001089194), closed, covered)
  launch_pad_Transmission_Launch_Pad_R = polyline(z=0, xy: (0.00204, -0.001105) (0.002162, -0.00114) (0.002242, -0.00114) (0.002242, -0.00106) (0.002162, -0.00106) (0.00204, -0.001095) (0.002015, -0.001095) (0.002015, -0.001105) (0.00204, -0.001105), closed, covered)
  pocket_Transmission_Launch_Pad_R = polyline(z=0, xy: (0.00204, -0.001110806) (0.002162, -0.001198) (0.0023, -0.001198) (0.0023, -0.001002) (0.002162, -0.001002) (0.00204, -0.001089194) (0.002015, -0.001089194) (0.002015, -0.001110806) (0.00204, -0.001110806), closed, covered)
  ground_main_plane = rectangle(corner=(-0.0025, -0.001398, 0), x_size=0.005, y_size=0.000596)
  main [silicon] = box(corner=(-0.0025, -0.001398, -0.00075), size=(0.005, 0.000596, 0.00075))
  sample_holder [vacuum] = box(corner=(-0.0025, -0.001398, -0.00165), size=(0.005, 0.000596, 0.00254))
  ground_main_plane.subtract(pocket_Transmission_Launch_Pad_L, cut_cpw_straight_line, pocket_Transmission_Launch_Pad_R)
  Rectangle1 = rectangle(corner=(-2.3mm, -1.002mm, 0mm), x_size=0.06mm, y_size=-0.198mm)
  Rectangle2 = rectangle(corner=(2.3mm, -1.002mm, 0mm), x_size=-0.06mm, y_size=-0.198mm)
boundaries and excitations:
  PerfE: Perfect E Objects=[trace_cpw_straight_line, launch_pad_Transmission_Launch_Pad_L, launch_pad_Transmission_Launch_Pad_R, ground_main_plane]
  1: Lumped Port Objects=Rectangle1 LumpedPortType=Modal Modes{Mode1{IntLine{(-2.24, -1.101, 0) -> (-2.3, -1.101, 0)} CharImp=Zpi RenormImp=port_impedance}} Impedance=port_impedance
  2: Lumped Port Objects=Rectangle2 LumpedPortType=Modal Modes{Mode1{IntLine{(2.3, -1.101, 0) -> (2.24, -1.101, 0)} CharImp=Zpi RenormImp=port_impedance}} Impedance=port_impedance
setups:
  Setup1: HfssDriven MultipleAdaptiveFreqsSetup{Low=4GHz High=8GHz} MaxDeltaS=0.004 MaximumPasses=45 MinimumPasses=25 MinimumConvergedPasses=3 PercentRefinement=20 BasisOrder=1 PortAccuracy=2 DrivenSolverType="Direct Solver"
    sweep Sweep: 4GHz to 8GHz, 21 points; Type=Discrete
source amplitudes:
  1:1: 1W 0deg
  2:1: 0W 0deg
optimetrics:
  ParametricSetup1: Parametric Sim._Setups=[Setup1]
    sweep port_impedance: LIN 47ohm 49ohm 0.1ohm LIN 40ohm 60ohm 5ohm LIN 45ohm 55ohm 1ohm
    calculate max(dB(S(1,1))) on Setup1 : LastAdaptive at Freq all
field plots:
  Mesh1: MeshPlots over Rectangle1.face Rectangle2.face ground_main_plane.face(at (0, -1.1, 0)) launch_pad_Transmission_Launch_Pad_L.face launch_pad_Transmission_Launch_Pad_R.face trace_cpw_straight_line.face on Setup1 : LastAdaptive at Freq=6GHz Phase=0deg
reports:
  S Parameter Plot 1: max(dB(S(1,1))) vs Pass on Setup1 : AdaptivePass [Freq=all port_impedance=all]
  S Parameter Plot 2: max(dB(S(1,1))) vs port_impedance on Setup1 : Sweep [Freq=all]
  S Parameter Plot 3: dB(S(1,1)) vs Freq on Setup1 : Sweep [port_impedance=all]
