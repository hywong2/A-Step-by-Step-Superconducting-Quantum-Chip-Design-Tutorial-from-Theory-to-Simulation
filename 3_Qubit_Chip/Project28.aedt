# Ansys Electronics Desktop project, version 2026.1
materials:
  vacuum: permittivity=1
  silicon: permittivity=11.9

design Full_Chip_Eigenmode (HFSS, Eigenmode, model units mm)
variables:
  Q0_top_Lj = 6.01nH
  Q0_top_Cj = 8fF
  Q1_top_Lj = 6.87nH
  Q1_top_Cj = 8fF
  Q0_bottom_Lj = 11.6nH
  Q0_bottom_Cj = 8fF
geometry:
  prime_cpw_TQ1_path = polyline((-0.0005, -0.0011, 0) (0, -0.0011, 0))
  prime_cpw_TQ1 = polyline((-0.0005, -0.001095, 0) (-0.0005, -0.001105, 0))
  prime_cpw_TQ1.sweep_along_path(prime_cpw_TQ1_path)
  prime_cpw_sub_TQ1_path = polyline((-0.0005, -0.0011, 0) (0, -0.0011, 0))
  prime_cpw_sub_TQ1 = polyline((-0.0005, -0.001089194, 0) (-0.0005, -0.001110806, 0))
  prime_cpw_sub_TQ1.sweep_along_path(prime_cpw_sub_TQ1_path)
  second_cpw_TQ1_path = polyline(z=0, xy: (-0.000375, -0.001124612) (-0.000125, -0.001124612) (-0.000125, -0.001224612))
  second_cpw_TQ1_path.fillet(Vertices=second_cpw_TQ1_path.vertex(at (-0.125, -1.12461, 0)) Radius=2.5e-05 Setback=0mm)
  second_cpw_TQ1 = polyline((-0.000375, -0.001119612, 0) (-0.000375, -0.001129612, 0))
  second_cpw_TQ1.sweep_along_path(second_cpw_TQ1_path)
  second_cpw_sub_TQ1_path = polyline(z=0, xy: (-0.000375, -0.001124612) (-0.000125, -0.001124612) (-0.000125, -0.001224612))
  second_cpw_sub_TQ1_path.fillet(Vertices=second_cpw_sub_TQ1_path.vertex(at (-0.125, -1.12461, 0)) Radius=2.5e-05 Setback=0mm)
  second_cpw_sub_TQ1 = polyline((-0.000375, -0.001113806, 0) (-0.000375, -0.001135418, 0))
  second_cpw_sub_TQ1.sweep_along_path(second_cpw_sub_TQ1_path)
  prime_cpw_TQ0_path = polyline((-0.0014, -0.0011, 0) (-0.0019, -0.0011, 0))
  prime_cpw_TQ0 = polyline((-0.0014, -0.001105, 0) (-0.0014, -0.001095, 0))
  prime_cpw_TQ0.sweep_along_path(prime_cpw_TQ0_path)
  prime_cpw_sub_TQ0_path = polyline((-0.0014, -0.0011, 0) (-0.0019, -0.0011, 0))
  prime_cpw_sub_TQ0 = polyline((-0.0014, -0.001110806, 0) (-0.0014, -0.001089194, 0))
  prime_cpw_sub_TQ0.sweep_along_path(prime_cpw_sub_TQ0_path)
  second_cpw_TQ0_path = polyline(z=0, xy: (-0.001775, -0.001075388) (-0.001525, -0.001075388) (-0.001525, -0.000975388))
  second_cpw_TQ0_path.fillet(Vertices=second_cpw_TQ0_path.vertex(at (-1.525, -1.07539, 0)) Radius=2.5e-05 Setback=0mm)
  second_cpw_TQ0 = polyline((-0.001775, -0.001070388, 0) (-0.001775, -0.001080388, 0))
  second_cpw_TQ0.sweep_along_path(second_cpw_TQ0_path)
  second_cpw_sub_TQ0_path = polyline(z=0, xy: (-0.001775, -0.001075388) (-0.001525, -0.001075388) (-0.001525, -0.000975388))
  second_cpw_sub_TQ0_path.fillet(Vertices=second_cpw_sub_TQ0_path.vertex(at (-1.525, -1.07539, 0)) Radius=2.5e-05 Setback=0mm)
  second_cpw_sub_TQ0 = polyline((-0.001775, -0.001064582, 0) (-0.001775, -0.001086194, 0))
  second_cpw_sub_TQ0.sweep_along_path(second_cpw_sub_TQ0_path)
  prime_cpw_TQ3_path = polyline((0.0019, -0.0011, 0) (0.0014, -0.0011, 0))
  prime_cpw_TQ3 = polyline((0.0019, -0.001105, 0) (0.0019, -0.001095, 0))
  prime_cpw_TQ3.sweep_along_path(prime_cpw_TQ3_path)
  prime_cpw_sub_TQ3_path = polyline((0.0019, -0.0011, 0) (0.0014, -0.0011, 0))
  prime_cpw_sub_TQ3 = polyline((0.0019, -0.001110806, 0) (0.0019, -0.001089194, 0))
  prime_cpw_sub_TQ3.sweep_along_path(prime_cpw_sub_TQ3_path)
  second_cpw_TQ3_path = polyline(z=0, xy: (0.001775, -0.001075388) (0.001525, -0.001075388) (0.001525, -0.000975388))
  second_cpw_TQ3_path.fillet(Vertices=second_cpw_TQ3_path.vertex(at (1.525, -1.07539, 0)) Radius=2.5e-05 Setback=0mm)
  second_cpw_TQ3 = polyline((0.001775, -0.001080388, 0) (0.001775, -0.001070388, 0))
  second_cpw_TQ3.sweep_along_path(second_cpw_TQ3_path)
  second_cpw_sub_TQ3_path = polyline(z=0, xy: (0.001775, -0.001075388) (0.001525, -0.001075388) (0.001525, -0.000975388))
  second_cpw_sub_TQ3_path.fillet(Vertices=second_cpw_sub_TQ3_path.vertex(at (1.525, -1.07539, 0)) Radius=2.5e-05 Setback=0mm)
  second_cpw_sub_TQ3 = polyline((0.001775, -0.001086194, 0) (0.001775, -0.001064582, 0))
  second_cpw_sub_TQ3.sweep_along_path(second_cpw_sub_TQ3_path)
  trace_cpw_left_path = polyline((0.002015, -0.0011, 0) (0, -0.0011, 0))
  trace_cpw_left = polyline((0.002015, -0.001105, 0) (0.002015, -0.001095, 0))
  trace_cpw_left.sweep_along_path(trace_cpw_left_path)
  cut_cpw_left_path = polyline((0.002015, -0.0011, 0) (0, -0.0011, 0))
  cut_cpw_left = polyline((0.002015, -0.001110806, 0) (0.002015, -0.001089194, 0))
  cut_cpw_left.sweep_along_path(cut_cpw_left_path)
  trace_cpw_right_path = polyline((-0.0005, -0.0011, 0) (-0.002015, -0.0011, 0))
  trace_cpw_right = polyline((-0.0005, -0.001105, 0) (-0.0005, -0.001095, 0))
  trace_cpw_right.sweep_along_path(trace_cpw_right_path)
  cut_cpw_right_path = polyline((-0.0005, -0.0011, 0) (-0.002015, -0.0011, 0))
  cut_cpw_right = polyline((-0.0005, -0.001110806, 0) (-0.0005, -0.001089194, 0))
  cut_cpw_right.sweep_along_path(cut_cpw_right_path)
  b_wire_Q0_bottom_path = polyline(z=0, xy: (-0.00145, -0.00158) (-0.001425, -0.00158) (-0.00133, -0.00158) (-0.001225, -0.00158))
  b_wire_Q0_bottom = polyline((-0.00145, -0.001575, 0) (-0.00145, -0.001585, 0))
  b_wire_Q0_bottom.sweep_along_path(b_wire_Q0_bottom_path)
  b_wire_sub_Q0_bottom_path = polyline(z=0, xy: (-0.00145, -0.00158) (-0.001425, -0.00158) (-0.00133, -0.00158) (-0.001225, -0.00158))
  b_wire_sub_Q0_bottom = polyline((-0.00145, -0.001569194, 0) (-0.00145, -0.001590806, 0))
  b_wire_sub_Q0_bottom.sweep_along_path(b_wire_sub_Q0_bottom_path)
  second_cpw_L_brackeb0_bottom_path = polyline(z=0, xy: (-0.00167, -0.001817959) (-0.00155, -0.001817959) (-0.00155, -0.001917959))
  second_cpw_L_brackeb0_bottom_path.fillet(Vertices=second_cpw_L_brackeb0_bottom_path.vertex(at (-1.55, -1.81796, 0)) Radius=9.9e-05 Setback=0mm)
  second_cpw_L_brackeb0_bottom = polyline((-0.00167, -0.001811959, 0) (-0.00167, -0.001823959, 0))
  second_cpw_L_brackeb0_bottom.sweep_along_path(second_cpw_L_brackeb0_bottom_path)
  second_cpw_sub_L_brackeb0_bottom_path = polyline(z=0, xy: (-0.00167, -0.001817959) (-0.00155, -0.001817959) (-0.00155, -0.001917959))
  second_cpw_sub_L_brackeb0_bottom_path.fillet(Vertices=second_cpw_sub_L_brackeb0_bottom_path.vertex(at (-1.55, -1.81796, 0)) Radius=9.9e-05 Setback=0mm)
  second_cpw_sub_L_brackeb0_bottom = polyline((-0.00167, -0.001805, 0) (-0.00167, -0.001830918, 0))
  second_cpw_sub_L_brackeb0_bottom.sweep_along_path(second_cpw_sub_L_brackeb0_bottom_path)
  trace_meander_Q0_bottom_path = polyline(z=0, xy: (-0.000125, -0.001224612) (-0.000125, -0.0016402618) (-0.000215, -0.0016402618) (-0.000215, -0.0012089622) (-0.000305, -0.0012089622) (-0.000305, -0.0016402618) (-0.000395, -0.0016402618) (-0.000395, -0.0012089622) (-0.000485, -0.0012089622) (-0.000485, -0.0016402618) (-0.000575, -0.0016402618) (-0.000575, -0.0012089622) (-0.000665, -0.0012089622) (-0.000665, -0.00158) (-0.001225, -0.00158))
  trace_meander_Q0_bottom_path.fillet(Vertices=trace_meander_Q0_bottom_path.vertex(at (-0.665, -1.58, 0), at (-0.665, -1.20896, 0), at (-0.575, -1.20896, 0), at (-0.575, -1.64026, 0), at (-0.485, -1.64026, 0), at (-0.485, -1.20896, 0), at (-0.395, -1.20896, 0), at (-0.395, -1.64026, 0), at (-0.305, -1.64026, 0), at (-0.305, -1.20896, 0), at (-0.215, -1.20896, 0), at (-0.215, -1.64026, 0)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) Radius=4e-05 Setback=0mm)
  trace_meander_Q0_bottom = polyline((-0.00012, -0.001224612, 0) (-0.00013, -0.001224612, 0))
  trace_meander_Q0_bottom.sweep_along_path(trace_meander_Q0_bottom_path)
  cut_meander_Q0_bottom_path = polyline(z=0, xy: (-0.000125, -0.001224612) (-0.000125, -0.0016402618) (-0.000215, -0.0016402618) (-0.000215, -0.0012089622) (-0.000305, -0.0012089622) (-0.000305, -0.0016402618) (-0.000395, -0.0016402618) (-0.000395, -0.0012089622) (-0.000485, -0.0012089622) (-0.000485, -0.0016402618) (-0.000575, -0.0016402618) (-0.000575, -0.0012089622) (-0.000665, -0.0012089622) (-0.000665, -0.00158) (-0.001225, -0.00158))
  cut_meander_Q0_bottom_path.fillet(Vertices=cut_meander_Q0_bottom_path.vertex(at (-0.665, -1.58, 0), at (-0.665, -1.20896, 0), at (-0.575, -1.20896, 0), at (-0.575, -1.64026, 0), at (-0.485, -1.64026, 0), at (-0.485, -1.20896, 0), at (-0.395, -1.20896, 0), at (-0.395, -1.64026, 0), at (-0.305, -1.64026, 0), at (-0.305, -1.20896, 0), at (-0.215, -1.20896, 0), at (-0.215, -1.64026, 0)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) Radius=4e-05 Setback=0mm)
  cut_meander_Q0_bottom = polyline((-0.000114194, -0.001224612, 0) (-0.000135806, -0.001224612, 0))
  cut_meander_Q0_bottom.sweep_along_path(cut_meander_Q0_bottom_path)
  trace_bias0_bottom_path = polyline(z=0, xy: (-0.00084, -0.002125) (-0.00084, -0.002017959) (-0.00155, -0.002017959) (-0.00155, -0.001917959))
  trace_bias0_bottom_path.fillet(Vertices=trace_bias0_bottom_path.vertex(at (-1.55, -2.01796, 0), at (-0.84, -2.01796, 0)) Radius=9.9e-05 Setback=0mm)
  trace_bias0_bottom = polyline((-0.000846, -0.002125, 0) (-0.000834, -0.002125, 0))
  trace_bias0_bottom.sweep_along_path(trace_bias0_bottom_path)
  cut_bias0_bottom_path = polyline(z=0, xy: (-0.00084, -0.002125) (-0.00084, -0.002017959) (-0.00155, -0.002017959) (-0.00155, -0.001917959))
  cut_bias0_bottom_path.fillet(Vertices=cut_bias0_bottom_path.vertex(at (-1.55, -2.01796, 0), at (-0.84, -2.01796, 0)) Radius=9.9e-05 Setback=0mm)
  cut_bias0_bottom = polyline((-0.000852959, -0.002125, 0) (-0.000827041, -0.002125, 0))
  cut_bias0_bottom.sweep_along_path(cut_bias0_bottom_path)
  a_wire_Q0_top_path = polyline(z=0, xy: (-0.0012, 7e-05) (-0.001225, 7e-05) (-0.00132, 7e-05) (-0.001425, 7e-05))
  a_wire_Q0_top = polyline((-0.0012, 6.5e-05, 0) (-0.0012, 7.5e-05, 0))
  a_wire_Q0_top.sweep_along_path(a_wire_Q0_top_path)
  a_wire_sub_Q0_top_path = polyline(z=0, xy: (-0.0012, 7e-05) (-0.001225, 7e-05) (-0.00132, 7e-05) (-0.001425, 7e-05))
  a_wire_sub_Q0_top = polyline((-0.0012, 5.9194e-05, 0) (-0.0012, 8.0806e-05, 0))
  a_wire_sub_Q0_top.sweep_along_path(a_wire_sub_Q0_top_path)
  b_wire_Q0_top_path = polyline(z=0, xy: (-0.0008, 7e-05) (-0.000775, 7e-05) (-0.00068, 7e-05) (-0.000575, 7e-05))
  b_wire_Q0_top = polyline((-0.0008, 7.5e-05, 0) (-0.0008, 6.5e-05, 0))
  b_wire_Q0_top.sweep_along_path(b_wire_Q0_top_path)
  b_wire_sub_Q0_top_path = polyline(z=0, xy: (-0.0008, 7e-05) (-0.000775, 7e-05) (-0.00068, 7e-05) (-0.000575, 7e-05))
  b_wire_sub_Q0_top = polyline((-0.0008, 8.0806e-05, 0) (-0.0008, 5.9194e-05, 0))
  b_wire_sub_Q0_top.sweep_along_path(b_wire_sub_Q0_top_path)
  second_cpw_L_bracket0_top_path = polyline(z=0, xy: (-0.00098, 0.000307959) (-0.0011, 0.000307959) (-0.0011, 0.000407959))
  second_cpw_L_bracket0_top_path.fillet(Vertices=second_cpw_L_bracket0_top_path.vertex(at (-1.1, 0.307959, 0)) Radius=9.9e-05 Setback=0mm)
  second_cpw_L_bracket0_top = polyline((-0.00098, 0.000301959, 0) (-0.00098, 0.000313959, 0))
  second_cpw_L_bracket0_top.sweep_along_path(second_cpw_L_bracket0_top_path)
  second_cpw_sub_L_bracket0_top_path = polyline(z=0, xy: (-0.00098, 0.000307959) (-0.0011, 0.000307959) (-0.0011, 0.000407959))
  second_cpw_sub_L_bracket0_top_path.fillet(Vertices=second_cpw_sub_L_bracket0_top_path.vertex(at (-1.1, 0.307959, 0)) Radius=9.9e-05 Setback=0mm)
  second_cpw_sub_L_bracket0_top = polyline((-0.00098, 0.000295, 0) (-0.00098, 0.000320918, 0))
  second_cpw_sub_L_bracket0_top.sweep_along_path(second_cpw_sub_L_bracket0_top_path)
  trace_bias0_top_path = polyline(z=0, xy: (-0.002015, 0.0011) (-0.0011, 0.0011) (-0.0011, 0.000407959))
  trace_bias0_top_path.fillet(Vertices=trace_bias0_top_path.vertex(at (-1.1, 1.1, 0)) Radius=9.9e-05 Setback=0mm)
  trace_bias0_top = polyline((-0.002015, 0.001106, 0) (-0.002015, 0.001094, 0))
  trace_bias0_top.sweep_along_path(trace_bias0_top_path)
  cut_bias0_top_path = polyline(z=0, xy: (-0.002015, 0.0011) (-0.0011, 0.0011) (-0.0011, 0.000407959))
  cut_bias0_top_path.fillet(Vertices=cut_bias0_top_path.vertex(at (-1.1, 1.1, 0)) Radius=9.9e-05 Setback=0mm)
  cut_bias0_top = polyline((-0.002015, 0.001112959, 0) (-0.002015, 0.001087041, 0))
  cut_bias0_top.sweep_along_path(cut_bias0_top_path)
  a_wire_Q1_top_path = polyline(z=0, xy: (0.0008, 7e-05) (0.000775, 7e-05) (0.00068, 7e-05) (0.000575, 7e-05))
  a_wire_Q1_top = polyline((0.0008, 6.5e-05, 0) (0.0008, 7.5e-05, 0))
  a_wire_Q1_top.sweep_along_path(a_wire_Q1_top_path)
  a_wire_sub_Q1_top_path = polyline(z=0, xy: (0.0008, 7e-05) (0.000775, 7e-05) (0.00068, 7e-05) (0.000575, 7e-05))
  a_wire_sub_Q1_top = polyline((0.0008, 5.9194e-05, 0) (0.0008, 8.0806e-05, 0))
  a_wire_sub_Q1_top.sweep_along_path(a_wire_sub_Q1_top_path)
  b_wire_Q1_top_path = polyline(z=0, xy: (0.0012, 7e-05) (0.001225, 7e-05) (0.00132, 7e-05) (0.001425, 7e-05))
  b_wire_Q1_top = polyline((0.0012, 7.5e-05, 0) (0.0012, 6.5e-05, 0))
  b_wire_Q1_top.sweep_along_path(b_wire_Q1_top_path)
  b_wire_sub_Q1_top_path = polyline(z=0, xy: (0.0012, 7e-05) (0.001225, 7e-05) (0.00132, 7e-05) (0.001425, 7e-05))
  b_wire_sub_Q1_top = polyline((0.0012, 8.0806e-05, 0) (0.0012, 5.9194e-05, 0))
  b_wire_sub_Q1_top.sweep_along_path(b_wire_sub_Q1_top_path)
  second_cpw_L_bracket1_top_path = polyline(z=0, xy: (0.00098, 0.000307959) (0.0011, 0.000307959) (0.0011, 0.000407959))
  second_cpw_L_bracket1_top_path.fillet(Vertices=second_cpw_L_bracket1_top_path.vertex(at (1.1, 0.307959, 0)) Radius=9.9e-05 Setback=0mm)
  second_cpw_L_bracket1_top = polyline((0.00098, 0.000313959, 0) (0.00098, 0.000301959, 0))
  second_cpw_L_bracket1_top.sweep_along_path(second_cpw_L_bracket1_top_path)
  second_cpw_sub_L_bracket1_top_path = polyline(z=0, xy: (0.00098, 0.000307959) (0.0011, 0.000307959) (0.0011, 0.000407959))
  second_cpw_sub_L_bracket1_top_path.fillet(Vertices=second_cpw_sub_L_bracket1_top_path.vertex(at (1.1, 0.307959, 0)) Radius=9.9e-05 Setback=0mm)
  second_cpw_sub_L_bracket1_top = polyline((0.00098, 0.000320918, 0) (0.00098, 0.000295, 0))
  second_cpw_sub_L_bracket1_top.sweep_along_path(second_cpw_sub_L_bracket1_top_path)
  trace_bias1_top_path = polyline(z=0, xy: (0.002015, 0.0011) (0.0011, 0.0011) (0.0011, 0.000407959))
  trace_bias1_top_path.fillet(Vertices=trace_bias1_top_path.vertex(at (1.1, 1.1, 0)) Radius=9.9e-05 Setback=0mm)
  trace_bias1_top = polyline((0.002015, 0.001094, 0) (0.002015, 0.001106, 0))
  trace_bias1_top.sweep_along_path(trace_bias1_top_path)
  cut_bias1_top_path = polyline(z=0, xy: (0.002015, 0.0011) (0.0011, 0.0011) (0.0011, 0.000407959))
  cut_bias1_top_path.fillet(Vertices=cut_bias1_top_path.vertex(at (1.1, 1.1, 0)) Radius=9.9e-05 Setback=0mm)
  cut_bias1_top = polyline((0.002015, 0.001087041, 0) (0.002015, 0.001112959, 0))
  cut_bias1_top.sweep_along_path(cut_bias1_top_path)
  trace_meander_Q0_top_path = polyline(z=0, xy: (-0.001525, -0.000975388) (-0.001525, -0.000875388) (-0.0019391851, -0.000875388) (-0.0019391851, -0.000775388) (-0.0017108149, -0.000775388) (-0.0017108149, -0.000675388) (-0.0019391851, -0.000675388) (-0.0019391851, -0.000575388) (-0.0017108149, -0.000575388) (-0.0017108149, -0.000475388) (-0.0019391851, -0.000475388) (-0.0019391851, -0.000375388) (-0.0017108149, -0.000375388) (-0.0017108149, -0.000275388) (-0.0019391851, -0.000275388) (-0.0019391851, -0.000175388) (-0.0017108149, -0.000175388) (-0.0017108149, -7.5388e-05) (-0.0018969229, -7.5388e-05) (-0.0018969229, 7e-05) (-0.001425, 7e-05))
  trace_meander_Q0_top_path.fillet(Vertices=trace_meander_Q0_top_path.vertex(at (-1.89692, 0.07, 0), at (-1.89692, -0.075388, 0), at (-1.71081, -0.075388, 0), at (-1.71081, -0.175388, 0), at (-1.93919, -0.175388, 0), at (-1.93919, -0.275388, 0), at (-1.71081, -0.275388, 0), at (-1.71081, -0.375388, 0), at (-1.93919, -0.375388, 0), at (-1.93919, -0.475388, 0), at (-1.71081, -0.475388, 0), at (-1.71081, -0.575388, 0)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) Radius=4e-05 Setback=0mm)
  trace_meander_Q0_top = polyline((-0.00153, -0.000975388, 0) (-0.00152, -0.000975388, 0))
  trace_meander_Q0_top.sweep_along_path(trace_meander_Q0_top_path)
  cut_meander_Q0_top_path = polyline(z=0, xy: (-0.001525, -0.000975388) (-0.001525, -0.000875388) (-0.0019391851, -0.000875388) (-0.0019391851, -0.000775388) (-0.0017108149, -0.000775388) (-0.0017108149, -0.000675388) (-0.0019391851, -0.000675388) (-0.0019391851, -0.000575388) (-0.0017108149, -0.000575388) (-0.0017108149, -0.000475388) (-0.0019391851, -0.000475388) (-0.0019391851, -0.000375388) (-0.0017108149, -0.000375388) (-0.0017108149, -0.000275388) (-0.0019391851, -0.000275388) (-0.0019391851, -0.000175388) (-0.0017108149, -0.000175388) (-0.0017108149, -7.5388e-05) (-0.0018969229, -7.5388e-05) (-0.0018969229, 7e-05) (-0.001425, 7e-05))
  cut_meander_Q0_top_path.fillet(Vertices=cut_meander_Q0_top_path.vertex(at (-1.89692, 0.07, 0), at (-1.89692, -0.075388, 0), at (-1.71081, -0.075388, 0), at (-1.71081, -0.175388, 0), at (-1.93919, -0.175388, 0), at (-1.93919, -0.275388, 0), at (-1.71081, -0.275388, 0), at (-1.71081, -0.375388, 0), at (-1.93919, -0.375388, 0), at (-1.93919, -0.475388, 0), at (-1.71081, -0.475388, 0), at (-1.71081, -0.575388, 0)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) Radius=4e-05 Setback=0mm)
  cut_meander_Q0_top = polyline((-0.001535806, -0.000975388, 0) (-0.001514194, -0.000975388, 0))
  cut_meander_Q0_top.sweep_along_path(cut_meander_Q0_top_path)
  trace_meander_Q1_top_path = polyline(z=0, xy: (0.001525, -0.000975388) (0.001525, -0.000785388) (0.0017988004, -0.000785388) (0.0017988004, -0.000695388) (0.0015511996, -0.000695388) (0.0015511996, -0.000605388) (0.0017988004, -0.000605388) (0.0017988004, -0.000515388) (0.0015511996, -0.000515388) (0.0015511996, -0.000425388) (0.0017988004, -0.000425388) (0.0017988004, -0.000335388) (0.0015511996, -0.000335388) (0.0015511996, -0.000245388) (0.0017988004, -0.000245388) (0.0017988004, -0.000155388) (0.0015511996, -0.000155388) (0.0015511996, -6.5388e-05) (0.001875, -6.5388e-05) (0.001875, 7e-05) (0.001425, 7e-05))
  trace_meander_Q1_top_path.fillet(Vertices=trace_meander_Q1_top_path.vertex(at (1.875, 0.07, 0), at (1.875, -0.065388, 0), at (1.5512, -0.065388, 0), at (1.5512, -0.155388, 0), at (1.7988, -0.155388, 0), at (1.7988, -0.245388, 0), at (1.5512, -0.245388, 0), at (1.5512, -0.335388, 0), at (1.7988, -0.335388, 0), at (1.7988, -0.425388, 0), at (1.5512, -0.425388, 0), at (1.5512, -0.515388, 0)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) Radius=4e-05 Setback=0mm)
  trace_meander_Q1_top = polyline((0.00152, -0.000975388, 0) (0.00153, -0.000975388, 0))
  trace_meander_Q1_top.sweep_along_path(trace_meander_Q1_top_path)
  cut_meander_Q1_top_path = polyline(z=0, xy: (0.001525, -0.000975388) (0.001525, -0.000785388) (0.0017988004, -0.000785388) (0.0017988004, -0.000695388) (0.0015511996, -0.000695388) (0.0015511996, -0.000605388) (0.0017988004, -0.000605388) (0.0017988004, -0.000515388) (0.0015511996, -0.000515388) (0.0015511996, -0.000425388) (0.0017988004, -0.000425388) (0.0017988004, -0.000335388) (0.0015511996, -0.000335388) (0.0015511996, -0.000245388) (0.0017988004, -0.000245388) (0.0017988004, -0.000155388) (0.0015511996, -0.000155388) (0.0015511996, -6.5388e-05) (0.001875, -6.5388e-05) (0.001875, 7e-05) (0.001425, 7e-05))
  cut_meander_Q1_top_path.fillet(Vertices=cut_meander_Q1_top_path.vertex(at (1.875, 0.07, 0), at (1.875, -0.065388, 0), at (1.5512, -0.065388, 0), at (1.5512, -0.155388, 0), at (1.7988, -0.155388, 0), at (1.7988, -0.245388, 0), at (1.5512, -0.245388, 0), at (1.5512, -0.335388, 0), at (1.7988, -0.335388, 0), at (1.7988, -0.425388, 0), at (1.5512, -0.425388, 0), at (1.5512, -0.515388, 0)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) Radius=4e-05 Setback=0mm)
  cut_meander_Q1_top = polyline((0.001514194, -0.000975388, 0) (0.001535806, -0.000975388, 0))
  cut_meander_Q1_top.sweep_along_path(cut_meander_Q1_top_path)
  trace_two_qubit_coupler_path = polyline(z=0, xy: (-0.000575, 7e-05) (-0.000475, 7e-05) (-0.000475, 0.00044463127) (-0.000385, 0.00044463127) (-0.000385, -0.00070463127) (-0.000295, -0.00070463127) (-0.000295, 0.00044463127) (-0.000205, 0.00044463127) (-0.000205, -0.00070463127) (-0.000115, -0.00070463127) (-0.000115, 0.00044463127) (-2.5e-05, 0.00044463127) (-2.5e-05, -0.00070463127) (6.5e-05, -0.00070463127) (6.5e-05, 0.00044463127) (0.000155, 0.00044463127) (0.000155, -0.00070463127) (0.000245, -0.00070463127) (0.000245, 0.00044463127) (0.000335, 0.00044463127) (0.000335, 7e-05) (0.000575, 7e-05))
  trace_two_qubit_coupler_path.fillet(Vertices=trace_two_qubit_coupler_path.vertex(at (0.335, 0.07, 0), at (0.335, 0.444631, 0), at (0.245, 0.444631, 0), at (0.245, -0.704631, 0), at (0.155, -0.704631, 0), at (0.155, 0.444631, 0), at (0.065, 0.444631, 0), at (0.065, -0.704631, 0), at (-0.025, -0.704631, 0), at (-0.025, 0.444631, 0), at (-0.115, 0.444631, 0), at (-0.115, -0.704631, 0)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) Radius=4e-05 Setback=0mm)
  trace_two_qubit_coupler = polyline((-0.000575, 7.5e-05, 0) (-0.000575, 6.5e-05, 0))
  trace_two_qubit_coupler.sweep_along_path(trace_two_qubit_coupler_path)
  cut_two_qubit_coupler_path = polyline(z=0, xy: (-0.000575, 7e-05) (-0.000475, 7e-05) (-0.000475, 0.00044463127) (-0.000385, 0.00044463127) (-0.000385, -0.00070463127) (-0.000295, -0.00070463127) (-0.000295, 0.00044463127) (-0.000205, 0.00044463127) (-0.000205, -0.00070463127) (-0.000115, -0.00070463127) (-0.000115, 0.00044463127) (-2.5e-05, 0.00044463127) (-2.5e-05, -0.00070463127) (6.5e-05, -0.00070463127) (6.5e-05, 0.00044463127) (0.000155, 0.00044463127) (0.000155, -0.00070463127) (0.000245, -0.00070463127) (0.000245, 0.00044463127) (0.000335, 0.00044463127) (0.000335, 7e-05) (0.000575, 7e-05))
  cut_two_qubit_coupler_path.fillet(Vertices=cut_two_qubit_coupler_path.vertex(at (0.335, 0.07, 0), at (0.335, 0.444631, 0), at (0.245, 0.444631, 0), at (0.245, -0.704631, 0), at (0.155, -0.704631, 0), at (0.155, 0.444631, 0), at (0.065, 0.444631, 0), at (0.065, -0.704631, 0), at (-0.025, -0.704631, 0), at (-0.025, 0.444631, 0), at (-0.115, 0.444631, 0), at (-0.115, -0.704631, 0)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) Radius=4e-05 Setback=0mm)
  cut_two_qubit_coupler = polyline((-0.000575, 8.0806e-05, 0) (-0.000575, 5.9194e-05, 0))
  cut_two_qubit_coupler.sweep_along_path(cut_two_qubit_coupler_path)
  launch_pad_Transmission_Launch_Pad_L = polyline(z=0, xy: (-0.00204, -0.001095) (-0.002162, -0.00106) (-0.002242, -0.00106) (-0.002242, -0.00114) (-0.002162, -0.00114) (-0.00204, -0.001105) (-0.002015, -0.001105) (-0.002015, -0.001095) (-0.00204, -0.001095), closed, covered)
  pocket_Transmission_Launch_Pad_L = polyline(z=0, xy: (-0.00204, -0.001089194) (-0.002162, -0.001002) (-0.0023, -0.001002) (-0.0023, -0.001198) (-0.002162, -0.001198) (-0.00204, -0.001110806) (-0.002015, -0.001110806) (-0.002015, -0.001089194) (-0.00204, -0.001089194), closed, covered)
  launch_pad_Transmission_Launch_Pad_R = polyline(z=0, xy: (0.00204, -0.001105) (0.002162, -0.00114) (0.002242, -0.00114) (0.002242, -0.00106) (0.002162, -0.00106) (0.00204, -0.001095) (0.002015, -0.001095) (0.002015, -0.001105) (0.00204, -0.001105), closed, covered)
  pocket_Transmission_Launch_Pad_R = polyline(z=0, xy: (0.00204, -0.001110806) (0.002162, -0.001198) (0.0023, -0.001198) (0.0023, -0.001002) (0.002162, -0.001002) (0.00204, -0.001089194) (0.002015, -0.001089194) (0.002015, -0.001110806) (0.00204, -0.001110806), closed, covered)
  launch_pad_Qubit_0_Top_Control_Launch_Pad = polyline(z=0, xy: (-0.00204, 0.001106) (-0.002162, 0.00114) (-0.002242, 0.00114) (-0.002242, 0.00106) (-0.002162, 0.00106) (-0.00204, 0.001094) (-0.002015, 0.001094) (-0.002015, 0.001106) (-0.00204, 0.001106), closed, covered)
  pocket_Qubit_0_Top_Control_Launch_Pad = polyline(z=0, xy: (-0.00204, 0.001111806) (-0.002162, 0.001198) (-0.0023, 0.001198) (-0.0023, 0.001002) (-0.002162, 0.001002) (-0.00204, 0.001088194) (-0.002015, 0.001088194) (-0.002015, 0.001111806) (-0.00204, 0.001111806), closed, covered)
  launch_pad_Qubit_1_Top_Control_Launch_Pad = polyline(z=0, xy: (0.00204, 0.001094) (0.002162, 0.00106) (0.002242, 0.00106) (0.002242, 0.00114) (0.002162, 0.00114) (0.00204, 0.001106) (0.002015, 0.001106) (0.002015, 0.001094) (0.00204, 0.001094), closed, covered)
  pocket_Qubit_1_Top_Control_Launch_Pad = polyline(z=0, xy: (0.00204, 0.001088194) (0.002162, 0.001002) (0.0023, 0.001002) (0.0023, 0.001198) (0.002162, 0.001198) (0.00204, 0.001111806) (0.002015, 0.001111806) (0.002015, 0.001088194) (0.00204, 0.001088194), closed, covered)
  pad_top_Q0_bottom = polyline(z=0, xy: (-0.0018549009, -0.0017297592) (-0.0018597545, -0.0017290393) (-0.0018645142, -0.001727847) (-0.0018691342, -0.001726194) (-0.0018735698, -0.0017240961) (-0.0018777785, -0.0017215735) (-0.0018817197, -0.0017186505) (-0.0018853553, -0.0017153553) (-0.0018886505, -0.0017117197) (-0.0018915735, -0.0017077785) (-0.0018940961, -0.0017035698) (-0.001896194, -0.0016991342) (-0.001897847, -0.0016945142) (-0.0018990393, -0.0016897545) (-0.0018997592, -0.0016849009) (-0.0019, -0.00168) (-0.0018997592, -0.0016750991) (-0.0018990393, -0.0016702455) (-0.001897847, -0.0016654858) (-0.001896194, -0.0016608658) (-0.0018940961, -0.0016564302) (-0.0018915735, -0.0016522215) (-0.0018886505, -0.0016482803) (-0.0018853553, -0.0016446447) (-0.0018817197, -0.0016413495) (-0.0018777785, -0.0016384265) (-0.0018735698, -0.0016359039) (-0.0018691342, -0.001633806) (-0.0018645142, -0.001632153) (-0.0018597545, -0.0016309607) (-0.0018549009, -0.0016302408) (-0.00185, -0.00163) (-0.00145, -0.00163) (-0.0014450991, -0.0016302408) (-0.0014402455, -0.0016309607) (-0.0014354858, -0.001632153) (-0.0014308658, -0.001633806) (-0.0014264302, -0.0016359039) (-0.0014222215, -0.0016384265) (-0.0014182803, -0.0016413495) (-0.0014146447, -0.0016446447) (-0.0014113495, -0.0016482803) (-0.0014084265, -0.0016522215) (-0.0014059039, -0.0016564302) (-0.001403806, -0.0016608658) (-0.001402153, -0.0016654858) (-0.0014009607, -0.0016702455) (-0.0014002408, -0.0016750991) (-0.0014, -0.00168) (-0.0014002408, -0.0016849009) (-0.0014009607, -0.0016897545) (-0.001402153, -0.0016945142) (-0.001403806, -0.0016991342) (-0.0014059039, -0.0017035698) (-0.0014084265, -0.0017077785) (-0.0014113495, -0.0017117197) (-0.0014146447, -0.0017153553) (-0.0014182803, -0.0017186505) (-0.0014222215, -0.0017215735) (-0.0014264302, -0.0017240961) (-0.0014308658, -0.001726194) (-0.0014354858, -0.001727847) (-0.0014402455, -0.0017290393) (-0.0014450991, -0.0017297592) (-0.00145, -0.00173) (-0.00185, -0.00173) (-0.0018549009, -0.0017297592), closed, covered)
  rect_pk_Q0_bottom = rectangle(corner=(-0.001975, -0.00179, 0), x_size=0.00065, y_size=0.000325)
  b_connector_pad_Q0_bottom = rectangle(corner=(-0.001575, -0.001585, 0), x_size=0.000125, y_size=1e-05)
  launch_pad_Launch_Pad_0_Bottom = polyline(z=0, xy: (-0.000846, -0.00215) (-0.00088, -0.002272) (-0.00088, -0.002352) (-0.0008, -0.002352) (-0.0008, -0.002272) (-0.000834, -0.00215) (-0.000834, -0.002125) (-0.000846, -0.002125) (-0.000846, -0.00215), closed, covered)
  pocket_Launch_Pad_0_Bottom = polyline(z=0, xy: (-0.000852959, -0.00215) (-0.000938, -0.002272) (-0.000938, -0.00241) (-0.000742, -0.00241) (-0.000742, -0.002272) (-0.000827041, -0.00215) (-0.000827041, -0.002125) (-0.000852959, -0.002125) (-0.000852959, -0.00215), closed, covered)
  pad_top_Q0_top = polyline(z=0, xy: (-0.00079509914, 0.00021975924) (-0.00079024548, 0.00021903926) (-0.00078548577, 0.00021784702) (-0.00078086583, 0.00021619398) (-0.00077643016, 0.00021409606) (-0.00077222149, 0.00021157348) (-0.00076828034, 0.00020865052) (-0.00076464466, 0.00020535534) (-0.00076134948, 0.00020171966) (-0.00075842652, 0.00019777851) (-0.00075590394, 0.00019356984) (-0.00075380602, 0.00018913417) (-0.00075215298, 0.00018451423) (-0.00075096074, 0.00017975452) (-0.00075024076, 0.00017490086) (-0.00075, 0.00017) (-0.00075024076, 0.00016509914) (-0.00075096074, 0.00016024548) (-0.00075215298, 0.00015548577) (-0.00075380602, 0.00015086583) (-0.00075590394, 0.00014643016) (-0.00075842652, 0.00014222149) (-0.00076134948, 0.00013828034) (-0.00076464466, 0.00013464466) (-0.00076828034, 0.00013134948) (-0.00077222149, 0.00012842652) (-0.00077643016, 0.00012590394) (-0.00078086583, 0.00012380602) (-0.00078548577, 0.00012215298) (-0.00079024548, 0.00012096074) (-0.00079509914, 0.00012024076) (-0.0008, 0.00012) (-0.0012, 0.00012) (-0.0012049009, 0.00012024076) (-0.0012097545, 0.00012096074) (-0.0012145142, 0.00012215298) (-0.0012191342, 0.00012380602) (-0.0012235698, 0.00012590394) (-0.0012277785, 0.00012842652) (-0.0012317197, 0.00013134948) (-0.0012353553, 0.00013464466) (-0.0012386505, 0.00013828034) (-0.0012415735, 0.00014222149) (-0.0012440961, 0.00014643016) (-0.001246194, 0.00015086583) (-0.001247847, 0.00015548577) (-0.0012490393, 0.00016024548) (-0.0012497592, 0.00016509914) (-0.00125, 0.00017) (-0.0012497592, 0.00017490086) (-0.0012490393, 0.00017975452) (-0.001247847, 0.00018451423) (-0.001246194, 0.00018913417) (-0.0012440961, 0.00019356984) (-0.0012415735, 0.00019777851) (-0.0012386505, 0.00020171966) (-0.0012353553, 0.00020535534) (-0.0012317197, 0.00020865052) (-0.0012277785, 0.00021157348) (-0.0012235698, 0.00021409606) (-0.0012191342, 0.00021619398) (-0.0012145142, 0.00021784702) (-0.0012097545, 0.00021903926) (-0.0012049009, 0.00021975924) (-0.0012, 0.00022) (-0.0008, 0.00022) (-0.00079509914, 0.00021975924), closed, covered)
  rect_pk_Q0_top = rectangle(corner=(-0.001325, -4.5e-05, 0), x_size=0.00065, y_size=0.000325)
  a_connector_pad_Q0_top = rectangle(corner=(-0.0012, 6.5e-05, 0), x_size=0.000125, y_size=1e-05)
  b_connector_pad_Q0_top = rectangle(corner=(-0.000801, 6.5e-05, 0), x_size=1e-06, y_size=1e-05)
  pad_top_Q1_top = polyline(z=0, xy: (0.0012049009, 0.00021975924) (0.0012097545, 0.00021903926) (0.0012145142, 0.00021784702) (0.0012191342, 0.00021619398) (0.0012235698, 0.00021409606) (0.0012277785, 0.00021157348) (0.0012317197, 0.00020865052) (0.0012353553, 0.00020535534) (0.0012386505, 0.00020171966) (0.0012415735, 0.00019777851) (0.0012440961, 0.00019356984) (0.001246194, 0.00018913417) (0.001247847, 0.00018451423) (0.0012490393, 0.00017975452) (0.0012497592, 0.00017490086) (0.00125, 0.00017) (0.0012497592, 0.00016509914) (0.0012490393, 0.00016024548) (0.001247847, 0.00015548577) (0.001246194, 0.00015086583) (0.0012440961, 0.00014643016) (0.0012415735, 0.00014222149) (0.0012386505, 0.00013828034) (0.0012353553, 0.00013464466) (0.0012317197, 0.00013134948) (0.0012277785, 0.00012842652) (0.0012235698, 0.00012590394) (0.0012191342, 0.00012380602) (0.0012145142, 0.00012215298) (0.0012097545, 0.00012096074) (0.0012049009, 0.00012024076) (0.0012, 0.00012) (0.0008, 0.00012) (0.00079509914, 0.00012024076) (0.00079024548, 0.00012096074) (0.00078548577, 0.00012215298) (0.00078086583, 0.00012380602) (0.00077643016, 0.00012590394) (0.00077222149, 0.00012842652) (0.00076828034, 0.00013134948) (0.00076464466, 0.00013464466) (0.00076134948, 0.00013828034) (0.00075842652, 0.00014222149) (0.00075590394, 0.00014643016) (0.00075380602, 0.00015086583) (0.00075215298, 0.00015548577) (0.00075096074, 0.00016024548) (0.00075024076, 0.00016509914) (0.00075, 0.00017) (0.00075024076, 0.00017490086) (0.00075096074, 0.00017975452) (0.00075215298, 0.00018451423) (0.00075380602, 0.00018913417) (0.00075590394, 0.00019356984) (0.00075842652, 0.00019777851) (0.00076134948, 0.00020171966) (0.00076464466, 0.00020535534) (0.00076828034, 0.00020865052) (0.00077222149, 0.00021157348) (0.00077643016, 0.00021409606) (0.00078086583, 0.00021619398) (0.00078548577, 0.00021784702) (0.00079024548, 0.00021903926) (0.00079509914, 0.00021975924) (0.0008, 0.00022) (0.0012, 0.00022) (0.0012049009, 0.00021975924), closed, covered)
  rect_pk_Q1_top = rectangle(corner=(0.000675, -4.5e-05, 0), x_size=0.00065, y_size=0.000325)
  a_connector_pad_Q1_top = rectangle(corner=(0.0008, 6.5e-05, 0), x_size=1e-06, y_size=1e-05)
  b_connector_pad_Q1_top = rectangle(corner=(0.001075, 6.5e-05, 0), x_size=0.000125, y_size=1e-05)
  JJ_rect_Lj_Q0_bottom_rect_jj_L = rectangle(corner=(-0.00168, -0.00179, 0), x_size=2e-05, y_size=6e-05)
  JJ_Lj_Q0_bottom_rect_jj_L_ = polyline((-0.00167, -0.00179, 0) (-0.00167, -0.00173, 0))
  JJ_rect_Lj_Q0_top_rect_jj_L = rectangle(corner=(-0.00099, 0.00022, 0), x_size=2e-05, y_size=6e-05)
  JJ_Lj_Q0_top_rect_jj_L_ = polyline((-0.00098, 0.00022, 0) (-0.00098, 0.00028, 0))
  JJ_rect_Lj_Q1_top_rect_jj_L = rectangle(corner=(0.00101, 0.00022, 0), x_size=2e-05, y_size=6e-05)
  JJ_Lj_Q1_top_rect_jj_L_ = polyline((0.00102, 0.00022, 0) (0.00102, 0.00028, 0))
  ground_main_plane = rectangle(corner=(-0.0025, -0.00261, 0), x_size=0.005, y_size=0.004008)
  main [silicon] = box(corner=(-0.0025, -0.00261, -0.00075), size=(0.005, 0.004008, 0.00075))
  sample_holder [vacuum] = box(corner=(-0.0025, -0.00261, -0.00165), size=(0.005, 0.004008, 0.00254))
  ground_main_plane.subtract(pocket_Transmission_Launch_Pad_L, a_wire_sub_Q0_top, cut_meander_Q1_top, second_cpw_sub_L_bracket0_top, pocket_Qubit_1_Top_Control_Launch_Pad, cut_meander_Q0_top, rect_pk_Q0_bottom, second_cpw_sub_TQ0, rect_pk_Q1_top, second_cpw_sub_TQ1, prime_cpw_sub_TQ3, pocket_Transmission_Launch_Pad_R, pocket_Launch_Pad_0_Bottom, cut_bias0_bottom, cut_meander_Q0_bottom, rect_pk_Q0_top, b_wire_sub_Q1_top, cut_cpw_left, cut_bias0_top, prime_cpw_sub_TQ1, prime_cpw_sub_TQ0, cut_bias1_top, pocket_Qubit_0_Top_Control_Launch_Pad, cut_two_qubit_coupler, a_wire_sub_Q1_top, second_cpw_sub_L_brackeb0_bottom, b_wire_sub_Q0_top, cut_cpw_right, second_cpw_sub_L_bracket1_top, b_wire_sub_Q0_bottom, second_cpw_sub_TQ3)
  Rectangle1 = rectangle(corner=(-2.3mm, -1.198mm, 0mm), x_size=0.058mm, y_size=0.196mm)
  Rectangle2 = rectangle(corner=(2.3mm, -1.002mm, 0mm), x_size=-0.058mm, y_size=-0.196mm)
  Rectangle3 = rectangle(corner=(-0.938mm, -2.41mm, 0mm), x_size=0.196mm, y_size=0.058mm)
  Rectangle4 = rectangle(corner=(2.3mm, 1.002mm, 0mm), x_size=-0.058mm, y_size=0.196mm)
  Rectangle5 = rectangle(corner=(-2.3mm, 1.002mm, 0mm), x_size=0.058mm, y_size=0.196mm)
boundaries and excitations:
  Lj_Lj_Q0_bottom_rect_jj_L: Lumped RLC Objects=JJ_rect_Lj_Q0_bottom_rect_jj_L CurrentLine{(-1.67, -1.79, 0) -> (-1.67, -1.73, 0)} RLC_Type=Parallel Inductance=Q0_bottom_Lj Capacitance=Q0_bottom_Cj
  Lj_Lj_Q0_top_rect_jj_L: Lumped RLC Objects=JJ_rect_Lj_Q0_top_rect_jj_L CurrentLine{(-0.98, 0.22, 0) -> (-0.98, 0.28, 0)} RLC_Type=Parallel Inductance=Q0_top_Lj Capacitance=Q0_top_Cj
  Lj_Lj_Q1_top_rect_jj_L: Lumped RLC Objects=JJ_rect_Lj_Q1_top_rect_jj_L CurrentLine{(1.02, 0.22, 0) -> (1.02, 0.28, 0)} RLC_Type=Parallel Inductance=Q1_top_Lj Capacitance=Q1_top_Cj
  PerfE: Perfect E Objects=[prime_cpw_TQ1, second_cpw_TQ1, prime_cpw_TQ0, second_cpw_TQ0, prime_cpw_TQ3, second_cpw_TQ3, trace_cpw_left, trace_cpw_right, b_wire_Q0_bottom, second_cpw_L_brackeb0_bottom, trace_meander_Q0_bottom, trace_bias0_bottom, a_wire_Q0_top, b_wire_Q0_top, second_cpw_L_bracket0_top, trace_bias0_top, a_wire_Q1_top, b_wire_Q1_top, second_cpw_L_bracket1_top, trace_bias1_top, trace_meander_Q0_top, trace_meander_Q1_top, trace_two_qubit_coupler, launch_pad_Transmission_Launch_Pad_L, launch_pad_Transmission_Launch_Pad_R, launch_pad_Qubit_0_Top_Control_Launch_Pad, launch_pad_Qubit_1_Top_Control_Launch_Pad, pad_top_Q0_bottom, b_connector_pad_Q0_bottom, launch_pad_Launch_Pad_0_Bottom, pad_top_Q0_top, a_connector_pad_Q0_top, b_connector_pad_Q0_top, pad_top_Q1_top, a_connector_pad_Q1_top, b_connector_pad_Q1_top, ground_main_plane]
  LumpRLC1: Lumped RLC Objects=Rectangle1 CurrentLine{(-2.3, -1.08, 0) -> (-2.242, -1.086, 0)} RLC_Type=Parallel Resistance=50ohm
  LumpRLC2: Lumped RLC Objects=Rectangle2 CurrentLine{(2.3, -1.102, 0) -> (2.242, -1.098, 0)} RLC_Type=Parallel Resistance=50ohm
  LumpRLC3: Lumped RLC Objects=Rectangle3 CurrentLine{(-0.835, -2.41, 0) -> (-0.834, -2.352, 0)} RLC_Type=Parallel Resistance=50ohm
  LumpRLC4: Lumped RLC Objects=Rectangle4 CurrentLine{(2.3, 1.09, 0) -> (2.242, 1.094, 0)} RLC_Type=Parallel Resistance=50ohm
  LumpRLC5: Lumped RLC Objects=Rectangle5 CurrentLine{(-2.3, 1.12, 0) -> (-2.242, 1.116, 0)} RLC_Type=Parallel Resistance=50ohm
mesh:
  small_mesh: LengthBased Objects=[JJ_rect_Lj_Q0_bottom_rect_jj_L, JJ_rect_Lj_Q0_top_rect_jj_L, JJ_rect_Lj_Q1_top_rect_jj_L] MaxLength=7um
setups:
  Setup: HfssEigen MinimumFrequency=1GHz NumModes=9 MaxDeltaFreq=1 ConvergeOnRealFreq=true MaximumPasses=15 MinimumPasses=1 MinimumConvergedPasses=1 PercentRefinement=30 BasisOrder=-1
source amplitudes:
  #-10:1..#-10:8: 0 0
  #-10:9: 1 0
field plots:
  Mag_E1: E Field on Setup : LastAdaptive at Phase=0deg
reports:
  Eigen Modes Plot1: re(Mode(1)), re(Mode(2)), re(Mode(3)), re(Mode(4)), re(Mode(5)), re(Mode(6)), re(Mode(7)), re(Mode(8)), re(Mode(9)) vs Pass on Setup : AdaptivePass
  Eigen Q Plot1: Q(1), Q(2), Q(3), Q(4), Q(5), Q(6), Q(7), Q(8), Q(9) vs Pass on Setup : AdaptivePass
  Freq. vs. pass: re(Mode(1)), re(Mode(2)), re(Mode(3)), re(Mode(4)), re(Mode(5)), re(Mode(6)), re(Mode(7)), re(Mode(8)), re(Mode(9)) vs Pass on Setup : AdaptivePass [Q0_bottom_Cj=8fF Q0_bottom_Lj=11.6nH Q0_top_Cj=8fF Q0_top_Lj=6.01nH Q1_top_Cj=8fF Q1_top_Lj=6.87nH]
