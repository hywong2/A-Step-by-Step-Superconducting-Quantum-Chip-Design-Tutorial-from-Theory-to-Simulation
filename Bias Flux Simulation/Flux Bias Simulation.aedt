# Ansys Electronics Desktop project, version 2026.1
materials:
  vacuum: permittivity=1
  silicon: permittivity=11.9
  pec: conductivity=1e+30

design sandwich_bottom_plate (HFSS, Eigenmode, model units mm)
geometry:
  b_wire_Q0_bottom_path = polyline(z=0, xy: (-0.00145, -0.00158) (-0.001425, -0.00158) (-0.00133, -0.00158) (-0.001225, -0.00158))
  b_wire_Q0_bottom = polyline((-0.00145, -0.001575, 0) (-0.00145, -0.001585, 0))
  b_wire_Q0_bottom.sweep_along_path(b_wire_Q0_bottom_path)
  b_wire_sub_Q0_bottom_path = polyline(z=0, xy: (-0.00145, -0.00158) (-0.001425, -0.00158) (-0.00133, -0.00158) (-0.001225, -0.00158))
  b_wire_sub_Q0_bottom = polyline((-0.00145, -0.001569194, 0) (-0.00145, -0.001590806, 0))
  b_wire_sub_Q0_bottom.sweep_along_path(b_wire_sub_Q0_bottom_path)
  second_cpw_L_brackeb0_bottom_path = polyline(z=0, xy: (-0.00167, -0.001817959) (-0.00155, -0.001817959) (-0.00155, -0.001917959))
  second_cpw_L_brackeb0_bottom_path.fillet(Vertices=second_cpw_L_brackeb0_bottom_path.vertex(at (-1.55, -1.81796, 0)) Radius=9.9e-05 Setback=0mm)
  second_cpw_L_brackeb0_bottom = polyline((-0.00167, -0.001811959, 0) (-0.00167, -0.001823959, 0))
  second_cpw_L_brackeb0_bottom.sweep_along_path(second_cpw_L_brackeb0_bottom_path)
  second_cpw_sub_L_brackeb0_bottom_path = polyline(z=0, xy: (-0.00167, -0.001817959) (-0.00155, -0.001817959) (-0.00155, -0.001917959))
  second_cpw_sub_L_brackeb0_bottom_path.fillet(Vertices=second_cpw_sub_L_brackeb0_bottom_path.vertex(at (-1.55, -1.81796, 0)) Radius=9.9e-05 Setback=0mm)
  second_cpw_sub_L_brackeb0_bottom = polyline((-0.00167, -0.001805, 0) (-0.00167, -0.001830918, 0))
  second_cpw_sub_L_brackeb0_bottom.sweep_along_path(second_cpw_sub_L_brackeb0_bottom_path)
  trace_bias0_bottom_path = polyline(z=0, xy: (-0.00084, -0.002125) (-0.00084, -0.002017959) (-0.00155, -0.002017959) (-0.00155, -0.001917959))
  trace_bias0_bottom_path.fillet(Vertices=trace_bias0_bottom_path.vertex(at (-1.55, -2.01796, 0), at (-0.84, -2.01796, 0)) Radius=9.9e-05 Setback=0mm)
  trace_bias0_bottom = polyline((-0.000846, -0.002125, 0) (-0.000834, -0.002125, 0))
  trace_bias0_bottom.sweep_along_path(trace_bias0_bottom_path)
  cut_bias0_bottom_path = polyline(z=0, xy: (-0.00084, -0.002125) (-0.00084, -0.002017959) (-0.00155, -0.002017959) (-0.00155, -0.001917959))
  cut_bias0_bottom_path.fillet(Vertices=cut_bias0_bottom_path.vertex(at (-1.55, -2.01796, 0), at (-0.84, -2.01796, 0)) Radius=9.9e-05 Setback=0mm)
  cut_bias0_bottom = polyline((-0.000852959, -0.002125, 0) (-0.000827041, -0.002125, 0))
  cut_bias0_bottom.sweep_along_path(cut_bias0_bottom_path)
  launch_pad_Launch_Pad_0_Bottom = polyline(z=0, xy: (-0.000846, -0.00215) (-0.00088, -0.002272) (-0.00088, -0.002352) (-0.0008, -0.002352) (-0.0008, -0.002272) (-0.000834, -0.00215) (-0.000834, -0.002125) (-0.000846, -0.002125) (-0.000846, -0.00215), closed, covered)
  pocket_Launch_Pad_0_Bottom = polyline(z=0, xy: (-0.000852959, -0.00215) (-0.000938, -0.002272) (-0.000938, -0.00241) (-0.000742, -0.00241) (-0.000742, -0.002272) (-0.000827041, -0.00215) (-0.000827041, -0.002125) (-0.000852959, -0.002125) (-0.000852959, -0.00215), closed, covered)
  pad_top_Q0_bottom = polyline(z=0, xy: (-0.0018549009, -0.0017297592) (-0.0018597545, -0.0017290393) (-0.0018645142, -0.001727847) (-0.0018691342, -0.001726194) (-0.0018735698, -0.0017240961) (-0.0018777785, -0.0017215735) (-0.0018817197, -0.0017186505) (-0.0018853553, -0.0017153553) (-0.0018886505, -0.0017117197) (-0.0018915735, -0.0017077785) (-0.0018940961, -0.0017035698) (-0.001896194, -0.0016991342) (-0.001897847, -0.0016945142) (-0.0018990393, -0.0016897545) (-0.0018997592, -0.0016849009) (-0.0019, -0.00168) (-0.0018997592, -0.0016750991) (-0.0018990393, -0.0016702455) (-0.001897847, -0.0016654858) (-0.001896194, -0.0016608658) (-0.0018940961, -0.0016564302) (-0.0018915735, -0.0016522215) (-0.0018886505, -0.0016482803) (-0.0018853553, -0.0016446447) (-0.0018817197, -0.0016413495) (-0.0018777785, -0.0016384265) (-0.0018735698, -0.0016359039) (-0.0018691342, -0.001633806) (-0.0018645142, -0.001632153) (-0.0018597545, -0.0016309607) (-0.0018549009, -0.0016302408) (-0.00185, -0.00163) (-0.00145, -0.00163) (-0.0014450991, -0.0016302408) (-0.0014402455, -0.0016309607) (-0.0014354858, -0.001632153) (-0.0014308658, -0.001633806) (-0.0014264302, -0.0016359039) (-0.0014222215, -0.0016384265) (-0.0014182803, -0.0016413495) (-0.0014146447, -0.0016446447) (-0.0014113495, -0.0016482803) (-0.0014084265, -0.0016522215) (-0.0014059039, -0.0016564302) (-0.001403806, -0.0016608658) (-0.001402153, -0.0016654858) (-0.0014009607, -0.0016702455) (-0.0014002408, -0.0016750991) (-0.0014, -0.00168) (-0.0014002408, -0.0016849009) (-0.0014009607, -0.0016897545) (-0.001402153, -0.0016945142) (-0.001403806, -0.0016991342) (-0.0014059039, -0.0017035698) (-0.0014084265, -0.0017077785) (-0.0014113495, -0.0017117197) (-0.0014146447, -0.0017153553) (-0.0014182803, -0.0017186505) (-0.0014222215, -0.0017215735) (-0.0014264302, -0.0017240961) (-0.0014308658, -0.001726194) (-0.0014354858, -0.001727847) (-0.0014402455, -0.0017290393) (-0.0014450991, -0.0017297592) (-0.00145, -0.00173) (-0.00185, -0.00173) (-0.0018549009, -0.0017297592), closed, covered)
  rect_pk_Q0_bottom = rectangle(corner=(-0.001975, -0.00179, 0), x_size=0.00065, y_size=0.000325)
  b_connector_pad_Q0_bottom = rectangle(corner=(-0.001575, -0.001585, 0), x_size=0.000125, y_size=1e-05)
  JJ_rect_Lj_Q0_bottom_rect_jj_R = rectangle(corner=(-0.00164, -0.00179, 0), x_size=2e-05, y_size=6e-05)
  JJ_Lj_Q0_bottom_rect_jj_R_ = polyline((-0.00163, -0.00179, 0) (-0.00163, -0.00173, 0))
  JJ_rect_Lj_Q0_bottom_rect_jj_L = rectangle(corner=(-0.00168, -0.00179, 0), x_size=2e-05, y_size=6e-05)
  JJ_Lj_Q0_bottom_rect_jj_L_ = polyline((-0.00167, -0.00179, 0) (-0.00167, -0.00173, 0))
  ground_main_plane = rectangle(corner=(-0.002175, -0.00261, 0), x_size=0.001633, y_size=0.001345)
  main [silicon] = box(corner=(-0.002175, -0.00261, -0.00075), size=(0.001633, 0.001345, 0.00075))
  sample_holder [vacuum] = box(corner=(-0.002175, -0.00261, -0.00165), size=(0.001633, 0.001345, 0.00254))
  ground_main_plane.subtract(second_cpw_sub_L_brackeb0_bottom, cut_bias0_bottom, pocket_Launch_Pad_0_Bottom, rect_pk_Q0_bottom, b_wire_sub_Q0_bottom)
boundaries and excitations:
  Lj_Lj_Q0_bottom_rect_jj_R: Lumped RLC Objects=JJ_rect_Lj_Q0_bottom_rect_jj_R CurrentLine{(-1.63, -1.79, 0) -> (-1.63, -1.73, 0)} RLC_Type=Parallel Inductance=10nH
  Lj_Lj_Q0_bottom_rect_jj_L: Lumped RLC Objects=JJ_rect_Lj_Q0_bottom_rect_jj_L CurrentLine{(-1.67, -1.79, 0) -> (-1.67, -1.73, 0)} RLC_Type=Parallel Inductance=10nH
  PerfE: Perfect E Objects=[b_wire_Q0_bottom, second_cpw_L_brackeb0_bottom, trace_bias0_bottom, launch_pad_Launch_Pad_0_Bottom, pad_top_Q0_bottom, b_connector_pad_Q0_bottom, ground_main_plane]
mesh:
  small_mesh: LengthBased Objects=[JJ_rect_Lj_Q0_bottom_rect_jj_R, JJ_rect_Lj_Q0_bottom_rect_jj_L] MaxLength=7um
setups:
  Setup: HfssEigen MinimumFrequency=1GHz NumModes=1 MaxDeltaFreq=0.1 ConvergeOnRealFreq=true MaximumPasses=10 MinimumPasses=1 MinimumConvergedPasses=1 PercentRefinement=30 BasisOrder=-1
source amplitudes:
  #-10:1: 1 0deg

design Maxwell3DDesign1 (Maxwell 3D, Magnetostatic, model units mm)
geometry:
  b_wire_Q0_bottom = polyline((-0.00145, -0.001575, 0) (-0.00145, -0.001585, 0))
  b_wire_Q0_bottom_path = polyline(z=0, xy: (-0.00145, -0.00158) (-0.001425, -0.00158) (-0.00133, -0.00158) (-0.001225, -0.00158))
  b_wire_Q0_bottom.sweep_along_path(b_wire_Q0_bottom_path)
  second_cpw_L_brackeb0_bottom [pec] = polyline((-0.00167, -0.001811959, 0) (-0.00167, -0.001823959, 0))
  second_cpw_L_brackeb0_bottom_path = polyline(z=0, xy: (-0.00167, -0.001817959) (-0.00155, -0.001817959) (-0.00155, -0.001917959))
  second_cpw_L_brackeb0_bottom_path.fillet(Vertices=second_cpw_L_brackeb0_bottom_path.vertex(at (-1.55, -1.81796, 0)) Radius=9.9e-05 Setback=0mm)
  second_cpw_L_brackeb0_bottom.sweep_along_path(second_cpw_L_brackeb0_bottom_path)
  trace_bias0_bottom [pec] = polyline((-0.000846, -0.002125, 0) (-0.000834, -0.002125, 0))
  trace_bias0_bottom_path = polyline(z=0, xy: (-0.00084, -0.002125) (-0.00084, -0.002017959) (-0.00155, -0.002017959) (-0.00155, -0.001917959))
  trace_bias0_bottom_path.fillet(Vertices=trace_bias0_bottom_path.vertex(at (-1.55, -2.01796, 0), at (-0.84, -2.01796, 0)) Radius=9.9e-05 Setback=0mm)
  trace_bias0_bottom.sweep_along_path(trace_bias0_bottom_path)
  launch_pad_Launch_Pad_0_Bottom [pec] = polyline(z=0, xy: (-0.000846, -0.00215) (-0.00088, -0.002272) (-0.00088, -0.002352) (-0.0008, -0.002352) (-0.0008, -0.002272) (-0.000834, -0.00215) (-0.000834, -0.002125) (-0.000846, -0.002125) (-0.000846, -0.00215), closed, covered)
  pad_top_Q0_bottom = polyline(z=0, xy: (-0.0018549009, -0.0017297592) (-0.0018597545, -0.0017290393) (-0.0018645142, -0.001727847) (-0.0018691342, -0.001726194) (-0.0018735698, -0.0017240961) (-0.0018777785, -0.0017215735) (-0.0018817197, -0.0017186505) (-0.0018853553, -0.0017153553) (-0.0018886505, -0.0017117197) (-0.0018915735, -0.0017077785) (-0.0018940961, -0.0017035698) (-0.001896194, -0.0016991342) (-0.001897847, -0.0016945142) (-0.0018990393, -0.0016897545) (-0.0018997592, -0.0016849009) (-0.0019, -0.00168) (-0.0018997592, -0.0016750991) (-0.0018990393, -0.0016702455) (-0.001897847, -0.0016654858) (-0.001896194, -0.0016608658) (-0.0018940961, -0.0016564302) (-0.0018915735, -0.0016522215) (-0.0018886505, -0.0016482803) (-0.0018853553, -0.0016446447) (-0.0018817197, -0.0016413495) (-0.0018777785, -0.0016384265) (-0.0018735698, -0.0016359039) (-0.0018691342, -0.001633806) (-0.0018645142, -0.001632153) (-0.0018597545, -0.0016309607) (-0.0018549009, -0.0016302408) (-0.00185, -0.00163) (-0.00145, -0.00163) (-0.0014450991, -0.0016302408) (-0.0014402455, -0.0016309607) (-0.0014354858, -0.001632153) (-0.0014308658, -0.001633806) (-0.0014264302, -0.0016359039) (-0.0014222215, -0.0016384265) (-0.0014182803, -0.0016413495) (-0.0014146447, -0.0016446447) (-0.0014113495, -0.0016482803) (-0.0014084265, -0.0016522215) (-0.0014059039, -0.0016564302) (-0.001403806, -0.0016608658) (-0.001402153, -0.0016654858) (-0.0014009607, -0.0016702455) (-0.0014002408, -0.0016750991) (-0.0014, -0.00168) (-0.0014002408, -0.0016849009) (-0.0014009607, -0.0016897545) (-0.001402153, -0.0016945142) (-0.001403806, -0.0016991342) (-0.0014059039, -0.0017035698) (-0.0014084265, -0.0017077785) (-0.0014113495, -0.0017117197) (-0.0014146447, -0.0017153553) (-0.0014182803, -0.0017186505) (-0.0014222215, -0.0017215735) (-0.0014264302, -0.0017240961) (-0.0014308658, -0.001726194) (-0.0014354858, -0.001727847) (-0.0014402455, -0.0017290393) (-0.0014450991, -0.0017297592) (-0.00145, -0.00173) (-0.00185, -0.00173) (-0.0018549009, -0.0017297592), closed, covered)
  b_connector_pad_Q0_bottom = rectangle(corner=(-0.001575, -0.001585, 0), x_size=0.000125, y_size=1e-05)
  JJ_rect_Lj_Q0_bottom_rect_jj_R = rectangle(corner=(-0.00164, -0.00179, 0), x_size=2e-05, y_size=6e-05)
  JJ_Lj_Q0_bottom_rect_jj_R_ = polyline((-0.00163, -0.00179, 0) (-0.00163, -0.00173, 0))
  JJ_rect_Lj_Q0_bottom_rect_jj_L = rectangle(corner=(-0.00168, -0.00179, 0), x_size=2e-05, y_size=6e-05)
  JJ_Lj_Q0_bottom_rect_jj_L_ = polyline((-0.00167, -0.00179, 0) (-0.00167, -0.00173, 0))
  ground_main_plane = rectangle(corner=(-0.002175, -0.00261, 0), x_size=0.001633, y_size=0.001345)
  second_cpw_sub_L_brackeb0_bottom = polyline((-0.00167, -0.001805, 0) (-0.00167, -0.001830918, 0))
  second_cpw_sub_L_brackeb0_bottom_path = polyline(z=0, xy: (-0.00167, -0.001817959) (-0.00155, -0.001817959) (-0.00155, -0.001917959))
  second_cpw_sub_L_brackeb0_bottom_path.fillet(Vertices=second_cpw_sub_L_brackeb0_bottom_path.vertex(at (-1.55, -1.81796, 0)) Radius=9.9e-05 Setback=0mm)
  second_cpw_sub_L_brackeb0_bottom.sweep_along_path(second_cpw_sub_L_brackeb0_bottom_path)
  cut_bias0_bottom = polyline((-0.000852959, -0.002125, 0) (-0.000827041, -0.002125, 0))
  cut_bias0_bottom_path = polyline(z=0, xy: (-0.00084, -0.002125) (-0.00084, -0.002017959) (-0.00155, -0.002017959) (-0.00155, -0.001917959))
  cut_bias0_bottom_path.fillet(Vertices=cut_bias0_bottom_path.vertex(at (-1.55, -2.01796, 0), at (-0.84, -2.01796, 0)) Radius=9.9e-05 Setback=0mm)
  cut_bias0_bottom.sweep_along_path(cut_bias0_bottom_path)
  pocket_Launch_Pad_0_Bottom = polyline(z=0, xy: (-0.000852959, -0.00215) (-0.000938, -0.002272) (-0.000938, -0.00241) (-0.000742, -0.00241) (-0.000742, -0.002272) (-0.000827041, -0.00215) (-0.000827041, -0.002125) (-0.000852959, -0.002125) (-0.000852959, -0.00215), closed, covered)
  rect_pk_Q0_bottom = rectangle(corner=(-0.001975, -0.00179, 0), x_size=0.00065, y_size=0.000325)
  b_wire_sub_Q0_bottom = polyline((-0.00145, -0.001569194, 0) (-0.00145, -0.001590806, 0))
  b_wire_sub_Q0_bottom_path = polyline(z=0, xy: (-0.00145, -0.00158) (-0.001425, -0.00158) (-0.00133, -0.00158) (-0.001225, -0.00158))
  b_wire_sub_Q0_bottom.sweep_along_path(b_wire_sub_Q0_bottom_path)
  ground_main_plane.subtract(second_cpw_sub_L_brackeb0_bottom, cut_bias0_bottom, pocket_Launch_Pad_0_Bottom, rect_pk_Q0_bottom, b_wire_sub_Q0_bottom)
  main [silicon] = box(corner=(-0.00167, -0.002352, -0.00075), size=(0.001633, 0.001345, 0.00075))
  sample_holder [vacuum] = box(corner=(-0.00167, -0.002352, -0.00165), size=(0.001633, 0.001345, 0.00254))
  [launch_pad_Launch_Pad_0_Bottom, trace_bias0_bottom, second_cpw_L_brackeb0_bottom].thicken(200nm)
  Rectangle1 [non-model] = rectangle(corner=(-1.67mm, -1.73mm, 0mm), x_size=0.04mm, y_size=-0.06mm)
boundaries and excitations:
  Current1: Current Faces=launch_pad_Launch_Pad_0_Bottom.face(at (-0.84, -2.352, 0.0001)) Current=1mA IsSolid=true Point_out_of_terminal=false
  Current2: Current Faces=second_cpw_L_brackeb0_bottom.face(at (-1.67, -1.81796, 0.0001)) Current=1mA IsSolid=true Point_out_of_terminal=true
setups:
  Setup1: Magnetostatic MaximumPasses=15 MinimumPasses=8 MinimumConvergedPasses=1 PercentRefinement=30 SolveFieldOnly PercentError=1 NonLinearResidual=0.001
field plots:
  Mag_B1: B over ground_main_plane.face(at (-1.3585, -1.9375, 0)) on Setup1 : LastAdaptive
  Mag_B2: B in main on Setup1 : LastAdaptive
