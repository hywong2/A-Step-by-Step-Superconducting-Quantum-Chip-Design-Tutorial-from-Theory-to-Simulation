# Ansys Electronics Desktop project, version 2026.1
materials:
  vacuum: permittivity=1
  silicon: permittivity=11.9
  copper: permeability=0.999991 conductivity=58000000
  pec: conductivity=1e+30

design TL_and_Resonator_Scatter1 (HFSS, Eigenmode, model units mm)
geometry:
  prime_cpw_TQ1_path = polyline((-0.0005, -0.0011, 0) (0, -0.0011, 0))
  prime_cpw_TQ1 = polyline((-0.0005, -0.001095, 0) (-0.0005, -0.001105, 0))
  prime_cpw_TQ1.sweep_along_path(prime_cpw_TQ1_path)
  prime_cpw_sub_TQ1_path = polyline((-0.0005, -0.0011, 0) (0, -0.0011, 0))
  prime_cpw_sub_TQ1 = polyline((-0.0005, -0.001089194, 0) (-0.0005, -0.001110806, 0))
  prime_cpw_sub_TQ1.sweep_along_path(prime_cpw_sub_TQ1_path)
  second_cpw_TQ1_path = polyline(z=0, xy: (-0.000375, -0.001124612) (-0.000125, -0.001124612) (-0.000125, -0.001224612))
  second_cpw_TQ1_path.fillet(Vertices=second_cpw_TQ1_path.vertex(at (-0.125, -1.12461, 0)) Radius=2.5e-05 Setback=0mm)
  second_cpw_TQ1 = polyline((-0.000375, -0.001119612, 0) (-0.000375, -0.001129612, 0))
  second_cpw_TQ1.sweep_along_path(second_cpw_TQ1_path)
  second_cpw_sub_TQ1_path = polyline(z=0, xy: (-0.000375, -0.001124612) (-0.000125, -0.001124612) (-0.000125, -0.001224612))
  second_cpw_sub_TQ1_path.fillet(Vertices=second_cpw_sub_TQ1_path.vertex(at (-0.125, -1.12461, 0)) Radius=2.5e-05 Setback=0mm)
  second_cpw_sub_TQ1 = polyline((-0.000375, -0.001113806, 0) (-0.000375, -0.001135418, 0))
  second_cpw_sub_TQ1.sweep_along_path(second_cpw_sub_TQ1_path)
  trace_cpw_left_path = polyline((0.002015, -0.0011, 0) (0, -0.0011, 0))
  trace_cpw_left = polyline((0.002015, -0.001105, 0) (0.002015, -0.001095, 0))
  trace_cpw_left.sweep_along_path(trace_cpw_left_path)
  cut_cpw_left_path = polyline((0.002015, -0.0011, 0) (0, -0.0011, 0))
  cut_cpw_left = polyline((0.002015, -0.001110806, 0) (0.002015, -0.001089194, 0))
  cut_cpw_left.sweep_along_path(cut_cpw_left_path)
  trace_cpw_right_path = polyline((-0.0005, -0.0011, 0) (-0.002015, -0.0011, 0))
  trace_cpw_right = polyline((-0.0005, -0.001105, 0) (-0.0005, -0.001095, 0))
  trace_cpw_right.sweep_along_path(trace_cpw_right_path)
  cut_cpw_right_path = polyline((-0.0005, -0.0011, 0) (-0.002015, -0.0011, 0))
  cut_cpw_right = polyline((-0.0005, -0.001110806, 0) (-0.0005, -0.001089194, 0))
  cut_cpw_right.sweep_along_path(cut_cpw_right_path)
  b_wire_Q0_bottom_path = polyline(z=0, xy: (-0.00145, -0.00158) (-0.001425, -0.00158) (-0.00133, -0.00158) (-0.001225, -0.00158))
  b_wire_Q0_bottom = polyline((-0.00145, -0.001575, 0) (-0.00145, -0.001585, 0))
  b_wire_Q0_bottom.sweep_along_path(b_wire_Q0_bottom_path)
  b_wire_sub_Q0_bottom_path = polyline(z=0, xy: (-0.00145, -0.00158) (-0.001425, -0.00158) (-0.00133, -0.00158) (-0.001225, -0.00158))
  b_wire_sub_Q0_bottom = polyline((-0.00145, -0.001569194, 0) (-0.00145, -0.001590806, 0))
  b_wire_sub_Q0_bottom.sweep_along_path(b_wire_sub_Q0_bottom_path)
  trace_meander_Q0_bottom_path = polyline(z=0, xy: (-0.000125, -0.001224612) (-0.000125, -0.0016402618) (-0.000215, -0.0016402618) (-0.000215, -0.0012089622) (-0.000305, -0.0012089622) (-0.000305, -0.0016402618) (-0.000395, -0.0016402618) (-0.000395, -0.0012089622) (-0.000485, -0.0012089622) (-0.000485, -0.0016402618) (-0.000575, -0.0016402618) (-0.000575, -0.0012089622) (-0.000665, -0.0012089622) (-0.000665, -0.00158) (-0.001225, -0.00158))
  trace_meander_Q0_bottom_path.fillet(Vertices=trace_meander_Q0_bottom_path.vertex(at (-0.665, -1.58, 0), at (-0.665, -1.20896, 0), at (-0.575, -1.20896, 0), at (-0.575, -1.64026, 0), at (-0.485, -1.64026, 0), at (-0.485, -1.20896, 0), at (-0.395, -1.20896, 0), at (-0.395, -1.64026, 0), at (-0.305, -1.64026, 0), at (-0.305, -1.20896, 0), at (-0.215, -1.20896, 0), at (-0.215, -1.64026, 0)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) Radius=4e-05 Setback=0mm)
  trace_meander_Q0_bottom = polyline((-0.00012, -0.001224612, 0) (-0.00013, -0.001224612, 0))
  trace_meander_Q0_bottom.sweep_along_path(trace_meander_Q0_bottom_path)
  cut_meander_Q0_bottom_path = polyline(z=0, xy: (-0.000125, -0.001224612) (-0.000125, -0.0016402618) (-0.000215, -0.0016402618) (-0.000215, -0.0012089622) (-0.000305, -0.0012089622) (-0.000305, -0.0016402618) (-0.000395, -0.0016402618) (-0.000395, -0.0012089622) (-0.000485, -0.0012089622) (-0.000485, -0.0016402618) (-0.000575, -0.0016402618) (-0.000575, -0.0012089622) (-0.000665, -0.0012089622) (-0.000665, -0.00158) (-0.001225, -0.00158))
  cut_meander_Q0_bottom_path.fillet(Vertices=cut_meander_Q0_bottom_path.vertex(at (-0.665, -1.58, 0), at (-0.665, -1.20896, 0), at (-0.575, -1.20896, 0), at (-0.575, -1.64026, 0), at (-0.485, -1.64026, 0), at (-0.485, -1.20896, 0), at (-0.395, -1.20896, 0), at (-0.395, -1.64026, 0), at (-0.305, -1.64026, 0), at (-0.305, -1.20896, 0), at (-0.215, -1.20896, 0), at (-0.215, -1.64026, 0)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) Radius=4e-05 Setback=0mm)
  cut_meander_Q0_bottom = polyline((-0.000114194, -0.001224612, 0) (-0.000135806, -0.001224612, 0))
  cut_meander_Q0_bottom.sweep_along_path(cut_meander_Q0_bottom_path)
  launch_pad_Transmission_Launch_Pad_L = polyline(z=0, xy: (-0.00204, -0.001095) (-0.002162, -0.00106) (-0.002242, -0.00106) (-0.002242, -0.00114) (-0.002162, -0.00114) (-0.00204, -0.001105) (-0.002015, -0.001105) (-0.002015, -0.001095) (-0.00204, -0.001095), closed, covered)
  pocket_Transmission_Launch_Pad_L = polyline(z=0, xy: (-0.00204, -0.001089194) (-0.002162, -0.001002) (-0.0023, -0.001002) (-0.0023, -0.001198) (-0.002162, -0.001198) (-0.00204, -0.001110806) (-0.002015, -0.001110806) (-0.002015, -0.001089194) (-0.00204, -0.001089194), closed, covered)
  launch_pad_Transmission_Launch_Pad_R = polyline(z=0, xy: (0.00204, -0.001105) (0.002162, -0.00114) (0.002242, -0.00114) (0.002242, -0.00106) (0.002162, -0.00106) (0.00204, -0.001095) (0.002015, -0.001095) (0.002015, -0.001105) (0.00204, -0.001105), closed, covered)
  pocket_Transmission_Launch_Pad_R = polyline(z=0, xy: (0.00204, -0.001110806) (0.002162, -0.001198) (0.0023, -0.001198) (0.0023, -0.001002) (0.002162, -0.001002) (0.00204, -0.001089194) (0.002015, -0.001089194) (0.002015, -0.001110806) (0.00204, -0.001110806), closed, covered)
  pad_top_Q0_bottom = polyline(z=0, xy: (-0.0018549009, -0.0017297592) (-0.0018597545, -0.0017290393) (-0.0018645142, -0.001727847) (-0.0018691342, -0.001726194) (-0.0018735698, -0.0017240961) (-0.0018777785, -0.0017215735) (-0.0018817197, -0.0017186505) (-0.0018853553, -0.0017153553) (-0.0018886505, -0.0017117197) (-0.0018915735, -0.0017077785) (-0.0018940961, -0.0017035698) (-0.001896194, -0.0016991342) (-0.001897847, -0.0016945142) (-0.0018990393, -0.0016897545) (-0.0018997592, -0.0016849009) (-0.0019, -0.00168) (-0.0018997592, -0.0016750991) (-0.0018990393, -0.0016702455) (-0.001897847, -0.0016654858) (-0.001896194, -0.0016608658) (-0.0018940961, -0.0016564302) (-0.0018915735, -0.0016522215) (-0.0018886505, -0.0016482803) (-0.0018853553, -0.0016446447) (-0.0018817197, -0.0016413495) (-0.0018777785, -0.0016384265) (-0.0018735698, -0.0016359039) (-0.0018691342, -0.001633806) (-0.0018645142, -0.001632153) (-0.0018597545, -0.0016309607) (-0.0018549009, -0.0016302408) (-0.00185, -0.00163) (-0.00145, -0.00163) (-0.0014450991, -0.0016302408) (-0.0014402455, -0.0016309607) (-0.0014354858, -0.001632153) (-0.0014308658, -0.001633806) (-0.0014264302, -0.0016359039) (-0.0014222215, -0.0016384265) (-0.0014182803, -0.0016413495) (-0.0014146447, -0.0016446447) (-0.0014113495, -0.0016482803) (-0.0014084265, -0.0016522215) (-0.0014059039, -0.0016564302) (-0.001403806, -0.0016608658) (-0.001402153, -0.0016654858) (-0.0014009607, -0.0016702455) (-0.0014002408, -0.0016750991) (-0.0014, -0.00168) (-0.0014002408, -0.0016849009) (-0.0014009607, -0.0016897545) (-0.001402153, -0.0016945142) (-0.001403806, -0.0016991342) (-0.0014059039, -0.0017035698) (-0.0014084265, -0.0017077785) (-0.0014113495, -0.0017117197) (-0.0014146447, -0.0017153553) (-0.0014182803, -0.0017186505) (-0.0014222215, -0.0017215735) (-0.0014264302, -0.0017240961) (-0.0014308658, -0.001726194) (-0.0014354858, -0.001727847) (-0.0014402455, -0.0017290393) (-0.0014450991, -0.0017297592) (-0.00145, -0.00173) (-0.00185, -0.00173) (-0.0018549009, -0.0017297592), closed, covered)
  rect_pk_Q0_bottom = rectangle(corner=(-0.001975, -0.00179, 0), x_size=0.00065, y_size=0.000325)
  b_connector_pad_Q0_bottom = rectangle(corner=(-0.001575, -0.001585, 0), x_size=0.000125, y_size=1e-05)
  JJ_rect_Lj_Q0_bottom_rect_jj_R = rectangle(corner=(-0.00164, -0.00179, 0), x_size=2e-05, y_size=6e-05)
  JJ_Lj_Q0_bottom_rect_jj_R_ = polyline((-0.00163, -0.00179, 0) (-0.00163, -0.00173, 0))
  JJ_rect_Lj_Q0_bottom_rect_jj_L = rectangle(corner=(-0.00168, -0.00179, 0), x_size=2e-05, y_size=6e-05)
  JJ_Lj_Q0_bottom_rect_jj_L_ = polyline((-0.00167, -0.00179, 0) (-0.00167, -0.00173, 0))
  ground_main_plane = rectangle(corner=(-0.0025, -0.00199, 0), x_size=0.005, y_size=0.001188)
  main [silicon] = box(corner=(-0.0025, -0.00199, -0.00075), size=(0.005, 0.001188, 0.00075))
  sample_holder [vacuum] = box(corner=(-0.0025, -0.00199, -0.00165), size=(0.005, 0.001188, 0.00254))
  ground_main_plane.subtract(cut_cpw_right, prime_cpw_sub_TQ1, b_wire_sub_Q0_bottom, second_cpw_sub_TQ1, cut_meander_Q0_bottom, rect_pk_Q0_bottom, pocket_Transmission_Launch_Pad_R, pocket_Transmission_Launch_Pad_L, cut_cpw_left)
boundaries and excitations:
  Lj_Lj_Q0_bottom_rect_jj_R: Lumped RLC Objects=JJ_rect_Lj_Q0_bottom_rect_jj_R CurrentLine{(-1.63, -1.79, 0) -> (-1.63, -1.73, 0)} RLC_Type=Parallel Inductance=10nH
  Lj_Lj_Q0_bottom_rect_jj_L: Lumped RLC Objects=JJ_rect_Lj_Q0_bottom_rect_jj_L CurrentLine{(-1.67, -1.79, 0) -> (-1.67, -1.73, 0)} RLC_Type=Parallel Inductance=10nH
  PerfE: Perfect E Objects=[prime_cpw_TQ1, second_cpw_TQ1, trace_cpw_left, trace_cpw_right, b_wire_Q0_bottom, trace_meander_Q0_bottom, launch_pad_Transmission_Launch_Pad_L, launch_pad_Transmission_Launch_Pad_R, pad_top_Q0_bottom, b_connector_pad_Q0_bottom, ground_main_plane]
mesh:
  small_mesh: LengthBased Objects=[JJ_rect_Lj_Q0_bottom_rect_jj_R, JJ_rect_Lj_Q0_bottom_rect_jj_L] MaxLength=7um
setups:
  Setup: HfssEigen MinimumFrequency=1GHz NumModes=1 MaxDeltaFreq=0.1 ConvergeOnRealFreq=true MaximumPasses=10 MinimumPasses=1 MinimumConvergedPasses=1 PercentRefinement=30 BasisOrder=-1
source amplitudes:
  #-10:1: 1 0deg

design Q3DDesign1 (Q3D Extractor, model units mm)
options: SParamCalcMethod=EqTransLine Calculate_Lossy_Dielectrics
geometry:
  prime_cpw_TQ1 = polyline((-0.0005, -0.001095, 0) (-0.0005, -0.001105, 0))
  prime_cpw_TQ1_path = polyline((-0.0005, -0.0011, 0) (0, -0.0011, 0))
  prime_cpw_TQ1.sweep_along_path(prime_cpw_TQ1_path)
  second_cpw_TQ1 = polyline((-0.000375, -0.001119612, 0) (-0.000375, -0.001129612, 0))
  second_cpw_TQ1_path = polyline(z=0, xy: (-0.000375, -0.001124612) (-0.000125, -0.001124612) (-0.000125, -0.001224612))
  second_cpw_TQ1_path.fillet(Vertices=second_cpw_TQ1_path.vertex(at (-0.125, -1.12461, 0)) Radius=2.5e-05 Setback=0mm)
  second_cpw_TQ1.sweep_along_path(second_cpw_TQ1_path)
  trace_cpw_left = polyline((0.002015, -0.001105, 0) (0.002015, -0.001095, 0))
  trace_cpw_left_path = polyline((0.002015, -0.0011, 0) (0, -0.0011, 0))
  trace_cpw_left.sweep_along_path(trace_cpw_left_path)
  trace_cpw_right = polyline((-0.0005, -0.001105, 0) (-0.0005, -0.001095, 0))
  trace_cpw_right_path = polyline((-0.0005, -0.0011, 0) (-0.002015, -0.0011, 0))
  trace_cpw_right.sweep_along_path(trace_cpw_right_path)
  b_wire_Q0_bottom = polyline((-0.00145, -0.001575, 0) (-0.00145, -0.001585, 0))
  b_wire_Q0_bottom_path = polyline(z=0, xy: (-0.00145, -0.00158) (-0.001425, -0.00158) (-0.00133, -0.00158) (-0.001225, -0.00158))
  b_wire_Q0_bottom.sweep_along_path(b_wire_Q0_bottom_path)
  trace_meander_Q0_bottom = polyline((-0.00012, -0.001224612, 0) (-0.00013, -0.001224612, 0))
  trace_meander_Q0_bottom_path = polyline(z=0, xy: (-0.000125, -0.001224612) (-0.000125, -0.0016402618) (-0.000215, -0.0016402618) (-0.000215, -0.0012089622) (-0.000305, -0.0012089622) (-0.000305, -0.0016402618) (-0.000395, -0.0016402618) (-0.000395, -0.0012089622) (-0.000485, -0.0012089622) (-0.000485, -0.0016402618) (-0.000575, -0.0016402618) (-0.000575, -0.0012089622) (-0.000665, -0.0012089622) (-0.000665, -0.00158) (-0.001225, -0.00158))
  trace_meander_Q0_bottom_path.fillet(Vertices=trace_meander_Q0_bottom_path.vertex(at (-0.665, -1.58, 0), at (-0.665, -1.20896, 0), at (-0.575, -1.20896, 0), at (-0.575, -1.64026, 0), at (-0.485, -1.64026, 0), at (-0.485, -1.20896, 0), at (-0.395, -1.20896, 0), at (-0.395, -1.64026, 0), at (-0.305, -1.64026, 0), at (-0.305, -1.20896, 0), at (-0.215, -1.20896, 0), at (-0.215, -1.64026, 0)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) Radius=4e-05 Setback=0mm)
  trace_meander_Q0_bottom.sweep_along_path(trace_meander_Q0_bottom_path)
  launch_pad_Transmission_Launch_Pad_L = polyline(z=0, xy: (-0.00204, -0.001095) (-0.002162, -0.00106) (-0.002242, -0.00106) (-0.002242, -0.00114) (-0.002162, -0.00114) (-0.00204, -0.001105) (-0.002015, -0.001105) (-0.002015, -0.001095) (-0.00204, -0.001095), closed, covered)
  launch_pad_Transmission_Launch_Pad_R = polyline(z=0, xy: (0.00204, -0.001105) (0.002162, -0.00114) (0.002242, -0.00114) (0.002242, -0.00106) (0.002162, -0.00106) (0.00204, -0.001095) (0.002015, -0.001095) (0.002015, -0.001105) (0.00204, -0.001105), closed, covered)
  pad_top_Q0_bottom = polyline(z=0, xy: (-0.0018549009, -0.0017297592) (-0.0018597545, -0.0017290393) (-0.0018645142, -0.001727847) (-0.0018691342, -0.001726194) (-0.0018735698, -0.0017240961) (-0.0018777785, -0.0017215735) (-0.0018817197, -0.0017186505) (-0.0018853553, -0.0017153553) (-0.0018886505, -0.0017117197) (-0.0018915735, -0.0017077785) (-0.0018940961, -0.0017035698) (-0.001896194, -0.0016991342) (-0.001897847, -0.0016945142) (-0.0018990393, -0.0016897545) (-0.0018997592, -0.0016849009) (-0.0019, -0.00168) (-0.0018997592, -0.0016750991) (-0.0018990393, -0.0016702455) (-0.001897847, -0.0016654858) (-0.001896194, -0.0016608658) (-0.0018940961, -0.0016564302) (-0.0018915735, -0.0016522215) (-0.0018886505, -0.0016482803) (-0.0018853553, -0.0016446447) (-0.0018817197, -0.0016413495) (-0.0018777785, -0.0016384265) (-0.0018735698, -0.0016359039) (-0.0018691342, -0.001633806) (-0.0018645142, -0.001632153) (-0.0018597545, -0.0016309607) (-0.0018549009, -0.0016302408) (-0.00185, -0.00163) (-0.00145, -0.00163) (-0.0014450991, -0.0016302408) (-0.0014402455, -0.0016309607) (-0.0014354858, -0.001632153) (-0.0014308658, -0.001633806) (-0.0014264302, -0.0016359039) (-0.0014222215, -0.0016384265) (-0.0014182803, -0.0016413495) (-0.0014146447, -0.0016446447) (-0.0014113495, -0.0016482803) (-0.0014084265, -0.0016522215) (-0.0014059039, -0.0016564302) (-0.001403806, -0.0016608658) (-0.001402153, -0.0016654858) (-0.0014009607, -0.0016702455) (-0.0014002408, -0.0016750991) (-0.0014, -0.00168) (-0.0014002408, -0.0016849009) (-0.0014009607, -0.0016897545) (-0.001402153, -0.0016945142) (-0.001403806, -0.0016991342) (-0.0014059039, -0.0017035698) (-0.0014084265, -0.0017077785) (-0.0014113495, -0.0017117197) (-0.0014146447, -0.0017153553) (-0.0014182803, -0.0017186505) (-0.0014222215, -0.0017215735) (-0.0014264302, -0.0017240961) (-0.0014308658, -0.001726194) (-0.0014354858, -0.001727847) (-0.0014402455, -0.0017290393) (-0.0014450991, -0.0017297592) (-0.00145, -0.00173) (-0.00185, -0.00173) (-0.0018549009, -0.0017297592), closed, covered)
  b_connector_pad_Q0_bottom = rectangle(corner=(-0.001575, -0.001585, 0), x_size=0.000125, y_size=1e-05)
  ground_main_plane = rectangle(corner=(-0.0025, -0.00199, 0), x_size=0.005, y_size=0.001188)
  cut_cpw_right = polyline((-0.0005, -0.001110806, 0) (-0.0005, -0.001089194, 0))
  cut_cpw_right_path = polyline((-0.0005, -0.0011, 0) (-0.002015, -0.0011, 0))
  cut_cpw_right.sweep_along_path(cut_cpw_right_path)
  prime_cpw_sub_TQ1 = polyline((-0.0005, -0.001089194, 0) (-0.0005, -0.001110806, 0))
  prime_cpw_sub_TQ1_path = polyline((-0.0005, -0.0011, 0) (0, -0.0011, 0))
  prime_cpw_sub_TQ1.sweep_along_path(prime_cpw_sub_TQ1_path)
  b_wire_sub_Q0_bottom = polyline((-0.00145, -0.001569194, 0) (-0.00145, -0.001590806, 0))
  b_wire_sub_Q0_bottom_path = polyline(z=0, xy: (-0.00145, -0.00158) (-0.001425, -0.00158) (-0.00133, -0.00158) (-0.001225, -0.00158))
  b_wire_sub_Q0_bottom.sweep_along_path(b_wire_sub_Q0_bottom_path)
  second_cpw_sub_TQ1 = polyline((-0.000375, -0.001113806, 0) (-0.000375, -0.001135418, 0))
  second_cpw_sub_TQ1_path = polyline(z=0, xy: (-0.000375, -0.001124612) (-0.000125, -0.001124612) (-0.000125, -0.001224612))
  second_cpw_sub_TQ1_path.fillet(Vertices=second_cpw_sub_TQ1_path.vertex(at (-0.125, -1.12461, 0)) Radius=2.5e-05 Setback=0mm)
  second_cpw_sub_TQ1.sweep_along_path(second_cpw_sub_TQ1_path)
  cut_meander_Q0_bottom = polyline((-0.000114194, -0.001224612, 0) (-0.000135806, -0.001224612, 0))
  cut_meander_Q0_bottom_path = polyline(z=0, xy: (-0.000125, -0.001224612) (-0.000125, -0.0016402618) (-0.000215, -0.0016402618) (-0.000215, -0.0012089622) (-0.000305, -0.0012089622) (-0.000305, -0.0016402618) (-0.000395, -0.0016402618) (-0.000395, -0.0012089622) (-0.000485, -0.0012089622) (-0.000485, -0.0016402618) (-0.000575, -0.0016402618) (-0.000575, -0.0012089622) (-0.000665, -0.0012089622) (-0.000665, -0.00158) (-0.001225, -0.00158))
  cut_meander_Q0_bottom_path.fillet(Vertices=cut_meander_Q0_bottom_path.vertex(at (-0.665, -1.58, 0), at (-0.665, -1.20896, 0), at (-0.575, -1.20896, 0), at (-0.575, -1.64026, 0), at (-0.485, -1.64026, 0), at (-0.485, -1.20896, 0), at (-0.395, -1.20896, 0), at (-0.395, -1.64026, 0), at (-0.305, -1.64026, 0), at (-0.305, -1.20896, 0), at (-0.215, -1.20896, 0), at (-0.215, -1.64026, 0)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) Radius=4e-05 Setback=0mm)
  cut_meander_Q0_bottom.sweep_along_path(cut_meander_Q0_bottom_path)
  rect_pk_Q0_bottom = rectangle(corner=(-0.001975, -0.00179, 0), x_size=0.00065, y_size=0.000325)
  pocket_Transmission_Launch_Pad_R = polyline(z=0, xy: (0.00204, -0.001110806) (0.002162, -0.001198) (0.0023, -0.001198) (0.0023, -0.001002) (0.002162, -0.001002) (0.00204, -0.001089194) (0.002015, -0.001089194) (0.002015, -0.001110806) (0.00204, -0.001110806), closed, covered)
  pocket_Transmission_Launch_Pad_L = polyline(z=0, xy: (-0.00204, -0.001089194) (-0.002162, -0.001002) (-0.0023, -0.001002) (-0.0023, -0.001198) (-0.002162, -0.001198) (-0.00204, -0.001110806) (-0.002015, -0.001110806) (-0.002015, -0.001089194) (-0.00204, -0.001089194), closed, covered)
  cut_cpw_left = polyline((0.002015, -0.001110806, 0) (0.002015, -0.001089194, 0))
  cut_cpw_left_path = polyline((0.002015, -0.0011, 0) (0, -0.0011, 0))
  cut_cpw_left.sweep_along_path(cut_cpw_left_path)
  ground_main_plane.subtract(cut_cpw_right, prime_cpw_sub_TQ1, b_wire_sub_Q0_bottom, second_cpw_sub_TQ1, cut_meander_Q0_bottom, rect_pk_Q0_bottom, pocket_Transmission_Launch_Pad_R, pocket_Transmission_Launch_Pad_L, cut_cpw_left)
  main [silicon] = box(corner=(-0.0025, -0.00199, -0.00075), size=(0.005, 0.001188, 0.00075))
  sample_holder [vacuum] = box(corner=(-0.0025, -0.00199, -0.00165), size=(0.005, 0.001188, 0.00254))
boundaries and excitations:
  ThinCond1: ThinConductor Objects=ground_main_plane Material=pec Thickness=200nm
  ThinCond2: ThinConductor Objects=pad_top_Q0_bottom Material=pec Thickness=200nm
  ThinCond3: ThinConductor Objects=[b_connector_pad_Q0_bottom, b_wire_Q0_bottom, trace_meander_Q0_bottom] Material=pec Thickness=200nm
  GND: SignalNet Objects=ground_main_plane
  Transmon: SignalNet Objects=pad_top_Q0_bottom
  Resonator: SignalNet Objects=[b_connector_pad_Q0_bottom, b_wire_Q0_bottom, trace_meander_Q0_bottom]
setups:
  Setup1: Matrix AdaptiveFreq=1GHz Cap{MaxPass=20 MinPass=10 MinConvPass=1 PerError=0.5 PerRefine=30 AutoIncreaseAccuracy AccuracyLevel=High Solver_Type=Iterative} ConstantDelta=0s ErrorValue=0.1
source amplitudes:
  GND: CG Fields 1V 0deg
  Resonator, Transmon: CG Fields 0V 0deg
reports:
  C Matrix Plot1: C(Transmon,GND) vs Pass on Setup1 : AdaptivePass [Freq=all]
