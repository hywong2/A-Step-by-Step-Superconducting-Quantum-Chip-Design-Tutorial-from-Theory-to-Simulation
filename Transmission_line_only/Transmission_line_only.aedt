# Ansys Electronics Desktop project, version 2026.1
materials:
  vacuum: permittivity=1
  silicon: permittivity=11.9

design my_tl (HFSS, HFSS Hybrid Modal Network, model units mm)
variables:
  portZ = 50ohm
geometry:
  trace_cpw_path = polyline((-0.001015, -0.0011, 0) (0.001015, -0.0011, 0))
  trace_cpw = polyline((-0.001015, -0.001095, 0) (-0.001015, -0.001105, 0))
  trace_cpw.sweep_along_path(trace_cpw_path)
  cut_cpw_path = polyline((-0.001015, -0.0011, 0) (0.001015, -0.0011, 0))
  cut_cpw = polyline((-0.001015, -0.001089194, 0) (-0.001015, -0.001110806, 0))
  cut_cpw.sweep_along_path(cut_cpw_path)
  launch_pad_Transmission_Launch_Pad_L = polyline(z=0, xy: (-0.00104, -0.001095) (-0.001162, -0.00106) (-0.001242, -0.00106) (-0.001242, -0.00114) (-0.001162, -0.00114) (-0.00104, -0.001105) (-0.001015, -0.001105) (-0.001015, -0.001095) (-0.00104, -0.001095), closed, covered)
  pocket_Transmission_Launch_Pad_L = polyline(z=0, xy: (-0.00104, -0.001089194) (-0.001162, -0.001002) (-0.0013, -0.001002) (-0.0013, -0.001198) (-0.001162, -0.001198) (-0.00104, -0.001110806) (-0.001015, -0.001110806) (-0.001015, -0.001089194) (-0.00104, -0.001089194), closed, covered)
  launch_pad_Transmission_Launch_Pad_R = polyline(z=0, xy: (0.00104, -0.001105) (0.001162, -0.00114) (0.001242, -0.00114) (0.001242, -0.00106) (0.001162, -0.00106) (0.00104, -0.001095) (0.001015, -0.001095) (0.001015, -0.001105) (0.00104, -0.001105), closed, covered)
  pocket_Transmission_Launch_Pad_R = polyline(z=0, xy: (0.00104, -0.001110806) (0.001162, -0.001198) (0.0013, -0.001198) (0.0013, -0.001002) (0.001162, -0.001002) (0.00104, -0.001089194) (0.001015, -0.001089194) (0.001015, -0.001110806) (0.00104, -0.001110806), closed, covered)
  ground_main_plane = rectangle(corner=(-0.0015, -0.001398, 0), x_size=0.003, y_size=0.000596)
  main [silicon] = box(corner=(-0.0015, -0.001398, -0.00075), size=(0.003, 0.000596, 0.00075))
  sample_holder [vacuum] = box(corner=(-0.0015, -0.001398, -0.00165), size=(0.003, 0.000596, 0.00254))
  ground_main_plane.subtract(cut_cpw, pocket_Transmission_Launch_Pad_L, pocket_Transmission_Launch_Pad_R)
  Rectangle1 = rectangle(corner=(-1.3mm, -1.198mm, 0mm), x_size=0.058mm, y_size=0.196mm)
  Rectangle2 = rectangle(corner=(1.3mm, -1.002mm, 0mm), x_size=-0.058mm, y_size=-0.196mm)
boundaries and excitations:
  PerfE: Perfect E Objects=[trace_cpw, launch_pad_Transmission_Launch_Pad_L, launch_pad_Transmission_Launch_Pad_R, ground_main_plane]
  1: Lumped Port Objects=Rectangle1 LumpedPortType=Default Modes{Mode1{IntLine{(-1.3, -1.085, 0) -> (-1.242, -1.09, 0)} CharImp=Zpi}} Impedance=portZ
  2: Lumped Port Objects=Rectangle2 LumpedPortType=Default Modes{Mode1{IntLine{(1.3, -1.115, 0) -> (1.242, -1.11, 0)} CharImp=Zpi}} Impedance=portZ
setups:
  Setup1: HfssDriven Frequency=5GHz MaxDeltaS=0.004 MaximumPasses=45 MinimumPasses=25 MinimumConvergedPasses=3 PercentRefinement=20 BasisOrder=1 PortAccuracy=2 DrivenSolverType="Direct Solver"
    sweep Sweep: 4GHz to 8GHz, 21 points; Type=Discrete
source amplitudes:
  1:1: 1W 0deg
  2:1: 0W 0deg
optimetrics:
  ParametricSetup1: Parametric Sim._Setups=[Setup1]
    sweep portZ: 51ohm 50.5ohm 49.5ohm
reports:
  S Parameter Plot1: dB(S(1,1)), dB(S(2,1)), dB(S(1,2)), dB(S(2,2)) vs Freq on Setup1 : Sweep
  S Parameter Plot2: dB(S(1,1)), dB(S(2,1)), dB(S(1,2)), dB(S(2,2)) vs Freq on Setup1 : Sweep [portZ=all]
