# Ansys Electronics Desktop project, version 2026.1
materials:
  vacuum: permittivity=1
  silicon: permittivity=11.9

design Full_Structure (HFSS, Eigenmode, model units mm)
variables:
  Q0_bottom_Lj = 11.1nH
  Q0_bottom_Cj = 8fF
geometry:
  prime_cpw_TQ1_path = polyline((-0.0005, -0.0011, 0) (0, -0.0011, 0))
  prime_cpw_TQ1 = polyline((-0.0005, -0.001095, 0) (-0.0005, -0.001105, 0))
  prime_cpw_TQ1.sweep_along_path(prime_cpw_TQ1_path)
  prime_cpw_sub_TQ1_path = polyline((-0.0005, -0.0011, 0) (0, -0.0011, 0))
  prime_cpw_sub_TQ1 = polyline((-0.0005, -0.001089194, 0) (-0.0005, -0.001110806, 0))
  prime_cpw_sub_TQ1.sweep_along_path(prime_cpw_sub_TQ1_path)
  second_cpw_TQ1_path = polyline(z=0, xy: (-0.000375, -0.001124612) (-0.000125, -0.001124612) (-0.000125, -0.001224612))
  second_cpw_TQ1_path.fillet(Vertices=second_cpw_TQ1_path.vertex(at (-0.125, -1.12461, 0)) Radius=2.5e-05 Setback=0mm)
  second_cpw_TQ1 = polyline((-0.000375, -0.001119612, 0) (-0.000375, -0.001129612, 0))
  second_cpw_TQ1.sweep_along_path(second_cpw_TQ1_path)
  second_cpw_sub_TQ1_path = polyline(z=0, xy: (-0.000375, -0.001124612) (-0.000125, -0.001124612) (-0.000125, -0.001224612))
  second_cpw_sub_TQ1_path.fillet(Vertices=second_cpw_sub_TQ1_path.vertex(at (-0.125, -1.12461, 0)) Radius=2.5e-05 Setback=0mm)
  second_cpw_sub_TQ1 = polyline((-0.000375, -0.001113806, 0) (-0.000375, -0.001135418, 0))
  second_cpw_sub_TQ1.sweep_along_path(second_cpw_sub_TQ1_path)
  trace_cpw_left_path = polyline((0.002015, -0.0011, 0) (0, -0.0011, 0))
  trace_cpw_left = polyline((0.002015, -0.001105, 0) (0.002015, -0.001095, 0))
  trace_cpw_left.sweep_along_path(trace_cpw_left_path)
  cut_cpw_left_path = polyline((0.002015, -0.0011, 0) (0, -0.0011, 0))
  cut_cpw_left = polyline((0.002015, -0.001110806, 0) (0.002015, -0.001089194, 0))
  cut_cpw_left.sweep_along_path(cut_cpw_left_path)
  trace_cpw_right_path = polyline((-0.0005, -0.0011, 0) (-0.002015, -0.0011, 0))
  trace_cpw_right = polyline((-0.0005, -0.001105, 0) (-0.0005, -0.001095, 0))
  trace_cpw_right.sweep_along_path(trace_cpw_right_path)
  cut_cpw_right_path = polyline((-0.0005, -0.0011, 0) (-0.002015, -0.0011, 0))
  cut_cpw_right = polyline((-0.0005, -0.001110806, 0) (-0.0005, -0.001089194, 0))
  cut_cpw_right.sweep_along_path(cut_cpw_right_path)
  b_wire_Q0_bottom_path = polyline(z=0, xy: (-0.00145, -0.00158) (-0.001425, -0.00158) (-0.00133, -0.00158) (-0.001225, -0.00158))
  b_wire_Q0_bottom = polyline((-0.00145, -0.001575, 0) (-0.00145, -0.001585, 0))
  b_wire_Q0_bottom.sweep_along_path(b_wire_Q0_bottom_path)
  b_wire_sub_Q0_bottom_path = polyline(z=0, xy: (-0.00145, -0.00158) (-0.001425, -0.00158) (-0.00133, -0.00158) (-0.001225, -0.00158))
  b_wire_sub_Q0_bottom = polyline((-0.00145, -0.001569194, 0) (-0.00145, -0.001590806, 0))
  b_wire_sub_Q0_bottom.sweep_along_path(b_wire_sub_Q0_bottom_path)
  second_cpw_L_brackeb0_bottom_path = polyline(z=0, xy: (-0.00167, -0.001817959) (-0.00155, -0.001817959) (-0.00155, -0.001917959))
  second_cpw_L_brackeb0_bottom_path.fillet(Vertices=second_cpw_L_brackeb0_bottom_path.vertex(at (-1.55, -1.81796, 0)) Radius=9.9e-05 Setback=0mm)
  second_cpw_L_brackeb0_bottom = polyline((-0.00167, -0.001811959, 0) (-0.00167, -0.001823959, 0))
  second_cpw_L_brackeb0_bottom.sweep_along_path(second_cpw_L_brackeb0_bottom_path)
  second_cpw_sub_L_brackeb0_bottom_path = polyline(z=0, xy: (-0.00167, -0.001817959) (-0.00155, -0.001817959) (-0.00155, -0.001917959))
  second_cpw_sub_L_brackeb0_bottom_path.fillet(Vertices=second_cpw_sub_L_brackeb0_bottom_path.vertex(at (-1.55, -1.81796, 0)) Radius=9.9e-05 Setback=0mm)
  second_cpw_sub_L_brackeb0_bottom = polyline((-0.00167, -0.001805, 0) (-0.00167, -0.001830918, 0))
  second_cpw_sub_L_brackeb0_bottom.sweep_along_path(second_cpw_sub_L_brackeb0_bottom_path)
  trace_meander_Q0_bottom_path = polyline(z=0, xy: (-0.000125, -0.001224612) (-0.000125, -0.0016402618) (-0.000215, -0.0016402618) (-0.000215, -0.0012089622) (-0.000305, -0.0012089622) (-0.000305, -0.0016402618) (-0.000395, -0.0016402618) (-0.000395, -0.0012089622) (-0.000485, -0.0012089622) (-0.000485, -0.0016402618) (-0.000575, -0.0016402618) (-0.000575, -0.0012089622) (-0.000665, -0.0012089622) (-0.000665, -0.00158) (-0.001225, -0.00158))
  trace_meander_Q0_bottom_path.fillet(Vertices=trace_meander_Q0_bottom_path.vertex(at (-0.665, -1.58, 0), at (-0.665, -1.20896, 0), at (-0.575, -1.20896, 0), at (-0.575, -1.64026, 0), at (-0.485, -1.64026, 0), at (-0.485, -1.20896, 0), at (-0.395, -1.20896, 0), at (-0.395, -1.64026, 0), at (-0.305, -1.64026, 0), at (-0.305, -1.20896, 0), at (-0.215, -1.20896, 0), at (-0.215, -1.64026, 0)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) Radius=4e-05 Setback=0mm)
  trace_meander_Q0_bottom = polyline((-0.00012, -0.001224612, 0) (-0.00013, -0.001224612, 0))
  trace_meander_Q0_bottom.sweep_along_path(trace_meander_Q0_bottom_path)
  cut_meander_Q0_bottom_path = polyline(z=0, xy: (-0.000125, -0.001224612) (-0.000125, -0.0016402618) (-0.000215, -0.0016402618) (-0.000215, -0.0012089622) (-0.000305, -0.0012089622) (-0.000305, -0.0016402618) (-0.000395, -0.0016402618) (-0.000395, -0.0012089622) (-0.000485, -0.0012089622) (-0.000485, -0.0016402618) (-0.000575, -0.0016402618) (-0.000575, -0.0012089622) (-0.000665, -0.0012089622) (-0.000665, -0.00158) (-0.001225, -0.00158))
  cut_meander_Q0_bottom_path.fillet(Vertices=cut_meander_Q0_bottom_path.vertex(at (-0.665, -1.58, 0), at (-0.665, -1.20896, 0), at (-0.575, -1.20896, 0), at (-0.575, -1.64026, 0), at (-0.485, -1.64026, 0), at (-0.485, -1.20896, 0), at (-0.395, -1.20896, 0), at (-0.395, -1.64026, 0), at (-0.305, -1.64026, 0), at (-0.305, -1.20896, 0), at (-0.215, -1.20896, 0), at (-0.215, -1.64026, 0)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) Radius=4e-05 Setback=0mm)
  cut_meander_Q0_bottom = polyline((-0.000114194, -0.001224612, 0) (-0.000135806, -0.001224612, 0))
  cut_meander_Q0_bottom.sweep_along_path(cut_meander_Q0_bottom_path)
  trace_bias0_bottom_path = polyline(z=0, xy: (-0.00084, -0.002125) (-0.00084, -0.002017959) (-0.00155, -0.002017959) (-0.00155, -0.001917959))
  trace_bias0_bottom_path.fillet(Vertices=trace_bias0_bottom_path.vertex(at (-1.55, -2.01796, 0), at (-0.84, -2.01796, 0)) Radius=9.9e-05 Setback=0mm)
  trace_bias0_bottom = polyline((-0.000846, -0.002125, 0) (-0.000834, -0.002125, 0))
  trace_bias0_bottom.sweep_along_path(trace_bias0_bottom_path)
  cut_bias0_bottom_path = polyline(z=0, xy: (-0.00084, -0.002125) (-0.00084, -0.002017959) (-0.00155, -0.002017959) (-0.00155, -0.001917959))
  cut_bias0_bottom_path.fillet(Vertices=cut_bias0_bottom_path.vertex(at (-1.55, -2.01796, 0), at (-0.84, -2.01796, 0)) Radius=9.9e-05 Setback=0mm)
  cut_bias0_bottom = polyline((-0.000852959, -0.002125, 0) (-0.000827041, -0.002125, 0))
  cut_bias0_bottom.sweep_along_path(cut_bias0_bottom_path)
  launch_pad_Transmission_Launch_Pad_L = polyline(z=0, xy: (-0.00204, -0.001095) (-0.002162, -0.00106) (-0.002242, -0.00106) (-0.002242, -0.00114) (-0.002162, -0.00114) (-0.00204, -0.001105) (-0.002015, -0.001105) (-0.002015, -0.001095) (-0.00204, -0.001095), closed, covered)
  pocket_Transmission_Launch_Pad_L = polyline(z=0, xy: (-0.00204, -0.001089194) (-0.002162, -0.001002) (-0.0023, -0.001002) (-0.0023, -0.001198) (-0.002162, -0.001198) (-0.00204, -0.001110806) (-0.002015, -0.001110806) (-0.002015, -0.001089194) (-0.00204, -0.001089194), closed, covered)
  launch_pad_Transmission_Launch_Pad_R = polyline(z=0, xy: (0.00204, -0.001105) (0.002162, -0.00114) (0.002242, -0.00114) (0.002242, -0.00106) (0.002162, -0.00106) (0.00204, -0.001095) (0.002015, -0.001095) (0.002015, -0.001105) (0.00204, -0.001105), closed, covered)
  pocket_Transmission_Launch_Pad_R = polyline(z=0, xy: (0.00204, -0.001110806) (0.002162, -0.001198) (0.0023, -0.001198) (0.0023, -0.001002) (0.002162, -0.001002) (0.00204, -0.001089194) (0.002015, -0.001089194) (0.002015, -0.001110806) (0.00204, -0.001110806), closed, covered)
  pad_top_Q0_bottom = polyline(z=0, xy: (-0.0018549009, -0.0017297592) (-0.0018597545, -0.0017290393) (-0.0018645142, -0.001727847) (-0.0018691342, -0.001726194) (-0.0018735698, -0.0017240961) (-0.0018777785, -0.0017215735) (-0.0018817197, -0.0017186505) (-0.0018853553, -0.0017153553) (-0.0018886505, -0.0017117197) (-0.0018915735, -0.0017077785) (-0.0018940961, -0.0017035698) (-0.001896194, -0.0016991342) (-0.001897847, -0.0016945142) (-0.0018990393, -0.0016897545) (-0.0018997592, -0.0016849009) (-0.0019, -0.00168) (-0.0018997592, -0.0016750991) (-0.0018990393, -0.0016702455) (-0.001897847, -0.0016654858) (-0.001896194, -0.0016608658) (-0.0018940961, -0.0016564302) (-0.0018915735, -0.0016522215) (-0.0018886505, -0.0016482803) (-0.0018853553, -0.0016446447) (-0.0018817197, -0.0016413495) (-0.0018777785, -0.0016384265) (-0.0018735698, -0.0016359039) (-0.0018691342, -0.001633806) (-0.0018645142, -0.001632153) (-0.0018597545, -0.0016309607) (-0.0018549009, -0.0016302408) (-0.00185, -0.00163) (-0.00145, -0.00163) (-0.0014450991, -0.0016302408) (-0.0014402455, -0.0016309607) (-0.0014354858, -0.001632153) (-0.0014308658, -0.001633806) (-0.0014264302, -0.0016359039) (-0.0014222215, -0.0016384265) (-0.0014182803, -0.0016413495) (-0.0014146447, -0.0016446447) (-0.0014113495, -0.0016482803) (-0.0014084265, -0.0016522215) (-0.0014059039, -0.0016564302) (-0.001403806, -0.0016608658) (-0.001402153, -0.0016654858) (-0.0014009607, -0.0016702455) (-0.0014002408, -0.0016750991) (-0.0014, -0.00168) (-0.0014002408, -0.0016849009) (-0.0014009607, -0.0016897545) (-0.001402153, -0.0016945142) (-0.001403806, -0.0016991342) (-0.0014059039, -0.0017035698) (-0.0014084265, -0.0017077785) (-0.0014113495, -0.0017117197) (-0.0014146447, -0.0017153553) (-0.0014182803, -0.0017186505) (-0.0014222215, -0.0017215735) (-0.0014264302, -0.0017240961) (-0.0014308658, -0.001726194) (-0.0014354858, -0.001727847) (-0.0014402455, -0.0017290393) (-0.0014450991, -0.0017297592) (-0.00145, -0.00173) (-0.00185, -0.00173) (-0.0018549009, -0.0017297592), closed, covered)
  rect_pk_Q0_bottom = rectangle(corner=(-0.001975, -0.00179, 0), x_size=0.00065, y_size=0.000325)
  b_connector_pad_Q0_bottom = rectangle(corner=(-0.001575, -0.001585, 0), x_size=0.000125, y_size=1e-05)
  launch_pad_Launch_Pad_0_Bottom = polyline(z=0, xy: (-0.000846, -0.00215) (-0.00088, -0.002272) (-0.00088, -0.002352) (-0.0008, -0.002352) (-0.0008, -0.002272) (-0.000834, -0.00215) (-0.000834, -0.002125) (-0.000846, -0.002125) (-0.000846, -0.00215), closed, covered)
  pocket_Launch_Pad_0_Bottom = polyline(z=0, xy: (-0.000852959, -0.00215) (-0.000938, -0.002272) (-0.000938, -0.00241) (-0.000742, -0.00241) (-0.000742, -0.002272) (-0.000827041, -0.00215) (-0.000827041, -0.002125) (-0.000852959, -0.002125) (-0.000852959, -0.00215), closed, covered)
  JJ_rect_Lj_Q0_bottom_rect_jj_R = rectangle(corner=(-0.00164, -0.00179, 0), x_size=2e-05, y_size=6e-05)
  JJ_Lj_Q0_bottom_rect_jj_R_ = polyline((-0.00163, -0.00179, 0) (-0.00163, -0.00173, 0))
  ground_main_plane = rectangle(corner=(-0.0025, -0.00261, 0), x_size=0.005, y_size=0.001808)
  main [silicon] = box(corner=(-0.0025, -0.00261, -0.00075), size=(0.005, 0.001808, 0.00075))
  sample_holder [vacuum] = box(corner=(-0.0025, -0.00261, -0.00165), size=(0.005, 0.001808, 0.00254))
  ground_main_plane.subtract(prime_cpw_sub_TQ1, pocket_Transmission_Launch_Pad_R, pocket_Launch_Pad_0_Bottom, second_cpw_sub_TQ1, b_wire_sub_Q0_bottom, cut_bias0_bottom, second_cpw_sub_L_brackeb0_bottom, cut_cpw_right, cut_cpw_left, pocket_Transmission_Launch_Pad_L, rect_pk_Q0_bottom, cut_meander_Q0_bottom)
boundaries and excitations:
  Lj_Lj_Q0_bottom_rect_jj_R: Lumped RLC Objects=JJ_rect_Lj_Q0_bottom_rect_jj_R CurrentLine{(-1.63, -1.79, 0) -> (-1.63, -1.73, 0)} RLC_Type=Parallel Inductance=Q0_bottom_Lj Capacitance=Q0_bottom_Cj
  PerfE: Perfect E Objects=[prime_cpw_TQ1, second_cpw_TQ1, trace_cpw_left, trace_cpw_right, b_wire_Q0_bottom, second_cpw_L_brackeb0_bottom, trace_meander_Q0_bottom, trace_bias0_bottom, launch_pad_Transmission_Launch_Pad_L, launch_pad_Transmission_Launch_Pad_R, pad_top_Q0_bottom, b_connector_pad_Q0_bottom, launch_pad_Launch_Pad_0_Bottom, ground_main_plane]
mesh:
  small_mesh: LengthBased Objects=JJ_rect_Lj_Q0_bottom_rect_jj_R MaxLength=7um
setups:
  Setup: HfssEigen MinimumFrequency=1GHz NumModes=6 MaxDeltaFreq=1 ConvergeOnRealFreq=true MaximumPasses=15 MinimumPasses=1 MinimumConvergedPasses=1 PercentRefinement=30 BasisOrder=-1
source amplitudes:
  #-10:1..#-10:5: 0 0
  #-10:6: 1 0
field plots:
  Mag_E1: E Field on Setup : LastAdaptive at Phase=0deg
reports:
  Eigen Modes Plot1: re(Mode(1)), re(Mode(2)), re(Mode(3)), re(Mode(4)), re(Mode(5)), re(Mode(6)) vs Pass on Setup : AdaptivePass
  Freq. vs. pass: re(Mode(1)), re(Mode(2)), re(Mode(3)), re(Mode(4)), re(Mode(5)), re(Mode(6)) vs Pass on Setup : AdaptivePass [Q0_bottom_Cj=8fF Q0_bottom_Lj=11.1nH]
